* fair-comparison p000000 dc
.option nomod method=gear reltol=1e-6 vntol=1e-9 abstol=1e-13 gmin=1e-12 itl1=200
.param VTHN=0.45126483051096039 VTHP=-0.43712328775058912 U0N=0.054472227924512562 U0P=0.019642227633496968 RDSWN=95.093588416662513 RDSWP=125.06632680402315 VSATN=87504.447322012653 VSATP=75147.443178696412 ETA0N=0.086119024107108172 ETA0P=0.072375500135660659 WS0=0.9297506302192986 WS1=1.0376459501931772 WS2=0.95303198059391914 WS3=1.02285909173834
.temp 25
.model NM NMOS (LEVEL=54 VERSION=4.7.0 TNOM=25 TOXE=1.5e-09 DTOX=0 EPSROX=3.8999999999999999 XJ=9.9999999999999995e-08 NSD=1e+20 NGATE=0 PHIN=0 K1=0.53000000000000003 K2=-0.018599999999999998 K3=0 K3B=0 W0=2.5000000000000002e-06 DVT0=2.2000000000000002 DVT1=0.53000000000000003 DVT2=-0.032000000000000001 DVT0W=0 DVT1W=5300000 DVT2W=-0.032000000000000001 UA=1.0000000000000001e-09 UB=1.0000000000000001e-18 UC=-4.6500000000000001e-11 A0=1 AGS=0 B0=0 B1=0 KETA=-0.047 A1=0 A2=1 PRWG=0 PRWB=0 WR=1 DWG=0 DWB=0 VOFF=-0.080000000000000002 NFACTOR=1 ETAB=-0.070000000000000007 PCLM=1.3 PDIBLC1=0.39000000000000001 PDIBLC2=0.0086 PDIBLCB=0 DROUT=0.56000000000000005 PVAG=0 DELTA=0.01 MOBMOD=0 CAPMOD=2 RDSMOD=0 RGATEMOD=0 NDEP=1.7e+17 VTH0='VTHN' U0='U0N' RDSW='RDSWN' VSAT='VSATN' ETA0='ETA0N')
.model PM PMOS (LEVEL=54 VERSION=4.7.0 TNOM=25 TOXE=1.5e-09 DTOX=0 EPSROX=3.8999999999999999 XJ=9.9999999999999995e-08 NSD=1e+20 NGATE=0 PHIN=0 K1=0.53000000000000003 K2=-0.018599999999999998 K3=0 K3B=0 W0=2.5000000000000002e-06 DVT0=2.2000000000000002 DVT1=0.53000000000000003 DVT2=-0.032000000000000001 DVT0W=0 DVT1W=5300000 DVT2W=-0.032000000000000001 UA=1.0000000000000001e-09 UB=1.0000000000000001e-18 UC=-4.6500000000000001e-11 A0=1 AGS=0 B0=0 B1=0 KETA=-0.047 A1=0 A2=1 PRWG=0 PRWB=0 WR=1 DWG=0 DWB=0 VOFF=-0.080000000000000002 NFACTOR=1 ETAB=-0.070000000000000007 PCLM=1.3 PDIBLC1=0.39000000000000001 PDIBLC2=0.0086 PDIBLCB=0 DROUT=0.56000000000000005 PVAG=0 DELTA=0.01 MOBMOD=0 CAPMOD=2 RDSMOD=0 RGATEMOD=0 NDEP=1.2e+17 VTH0='VTHP' U0='U0P' RDSW='RDSWP' VSAT='VSATP' ETA0='ETA0P')
VDD vdd 0 1.8
EA00 a00 0 vdd 0 1
VA01 a01 0 0
EA02 a02 0 vdd 0 1
VA03 a03 0 0
VA04 a04 0 0
EA05 a05 0 vdd 0 1
VA06 a06 0 0
EA07 a07 0 vdd 0 1
EA08 a08 0 vdd 0 1
VA09 a09 0 0
EA10 a10 0 vdd 0 1
VA11 a11 0 0
VA12 a12 0 0
EA13 a13 0 vdd 0 1
VA14 a14 0 0
EA15 a15 0 vdd 0 1
VB00 b00 0 0
VB01 b01 0 0
EB02 b02 0 vdd 0 1
EB03 b03 0 vdd 0 1
EB04 b04 0 vdd 0 1
EB05 b05 0 vdd 0 1
VB06 b06 0 0
VB07 b07 0 0
VB08 b08 0 0
EB09 b09 0 vdd 0 1
VB10 b10 0 0
EB11 b11 0 vdd 0 1
EB12 b12 0 vdd 0 1
VB13 b13 0 0
EB14 b14 0 vdd 0 1
VB15 b15 0 0
ECIN cin 0 vdd 0 1
MN_FA00_X0_IA FA00_X0_ab a00 0 0 NM W='1.1999999999999999e-06*WS0' L=1.8e-7
MP_FA00_X0_IA FA00_X0_ab a00 vdd vdd PM W='2.3999999999999999e-06*WS0' L=1.8e-7
MN_FA00_X0_IB FA00_X0_bb b00 0 0 NM W='1.1999999999999999e-06*WS0' L=1.8e-7
MP_FA00_X0_IB FA00_X0_bb b00 vdd vdd PM W='2.3999999999999999e-06*WS0' L=1.8e-7
MN_FA00_X0_00A p00 FA00_X0_ab FA00_X0_n00 0 NM W='1.7999999999999999e-06*WS1' L=1.8e-7
MN_FA00_X0_00B FA00_X0_n00 FA00_X0_bb 0 0 NM W='1.7999999999999999e-06*WS1' L=1.8e-7
MN_FA00_X0_11A p00 a00 FA00_X0_n11 0 NM W='1.7999999999999999e-06*WS1' L=1.8e-7
MN_FA00_X0_11B FA00_X0_n11 b00 0 0 NM W='1.7999999999999999e-06*WS1' L=1.8e-7
MP_FA00_X0_01A p00 a00 FA00_X0_p01 vdd PM W='3.5999999999999998e-06*WS1' L=1.8e-7
MP_FA00_X0_01B FA00_X0_p01 FA00_X0_bb vdd vdd PM W='3.5999999999999998e-06*WS1' L=1.8e-7
MP_FA00_X0_10A p00 FA00_X0_ab FA00_X0_p10 vdd PM W='3.5999999999999998e-06*WS1' L=1.8e-7
MP_FA00_X0_10B FA00_X0_p10 b00 vdd vdd PM W='3.5999999999999998e-06*WS1' L=1.8e-7
MN_FA00_X1_IA FA00_X1_ab p00 0 0 NM W='1.1999999999999999e-06*WS0' L=1.8e-7
MP_FA00_X1_IA FA00_X1_ab p00 vdd vdd PM W='2.3999999999999999e-06*WS0' L=1.8e-7
MN_FA00_X1_IB FA00_X1_bb cin 0 0 NM W='1.1999999999999999e-06*WS0' L=1.8e-7
MP_FA00_X1_IB FA00_X1_bb cin vdd vdd PM W='2.3999999999999999e-06*WS0' L=1.8e-7
MN_FA00_X1_00A sum00 FA00_X1_ab FA00_X1_n00 0 NM W='1.7999999999999999e-06*WS1' L=1.8e-7
MN_FA00_X1_00B FA00_X1_n00 FA00_X1_bb 0 0 NM W='1.7999999999999999e-06*WS1' L=1.8e-7
MN_FA00_X1_11A sum00 p00 FA00_X1_n11 0 NM W='1.7999999999999999e-06*WS1' L=1.8e-7
MN_FA00_X1_11B FA00_X1_n11 cin 0 0 NM W='1.7999999999999999e-06*WS1' L=1.8e-7
MP_FA00_X1_01A sum00 p00 FA00_X1_p01 vdd PM W='3.5999999999999998e-06*WS1' L=1.8e-7
MP_FA00_X1_01B FA00_X1_p01 FA00_X1_bb vdd vdd PM W='3.5999999999999998e-06*WS1' L=1.8e-7
MP_FA00_X1_10A sum00 FA00_X1_ab FA00_X1_p10 vdd PM W='3.5999999999999998e-06*WS1' L=1.8e-7
MP_FA00_X1_10B FA00_X1_p10 cin vdd vdd PM W='3.5999999999999998e-06*WS1' L=1.8e-7
MN_FA00_NAB_A nab00 a00 FA00_NAB_mid 0 NM W='2.3999999999999999e-06*WS2' L=1.8e-7
MN_FA00_NAB_B FA00_NAB_mid b00 0 0 NM W='2.3999999999999999e-06*WS2' L=1.8e-7
MP_FA00_NAB_A nab00 a00 vdd vdd PM W='4.7999999999999998e-06*WS2' L=1.8e-7
MP_FA00_NAB_B nab00 b00 vdd vdd PM W='4.7999999999999998e-06*WS2' L=1.8e-7
MN_FA00_NPC_A npc00 p00 FA00_NPC_mid 0 NM W='2.3999999999999999e-06*WS2' L=1.8e-7
MN_FA00_NPC_B FA00_NPC_mid cin 0 0 NM W='2.3999999999999999e-06*WS2' L=1.8e-7
MP_FA00_NPC_A npc00 p00 vdd vdd PM W='4.7999999999999998e-06*WS2' L=1.8e-7
MP_FA00_NPC_B npc00 cin vdd vdd PM W='4.7999999999999998e-06*WS2' L=1.8e-7
MN_FA00_COUT_A c01 nab00 FA00_COUT_mid 0 NM W='7.9999999999999996e-06*WS3' L=1.8e-7
MN_FA00_COUT_B FA00_COUT_mid npc00 0 0 NM W='7.9999999999999996e-06*WS3' L=1.8e-7
MP_FA00_COUT_A c01 nab00 vdd vdd PM W='1.5999999999999999e-05*WS3' L=1.8e-7
MP_FA00_COUT_B c01 npc00 vdd vdd PM W='1.5999999999999999e-05*WS3' L=1.8e-7
MN_FA01_X0_IA FA01_X0_ab a01 0 0 NM W='1.1999999999999999e-06*WS0' L=1.8e-7
MP_FA01_X0_IA FA01_X0_ab a01 vdd vdd PM W='2.3999999999999999e-06*WS0' L=1.8e-7
MN_FA01_X0_IB FA01_X0_bb b01 0 0 NM W='1.1999999999999999e-06*WS0' L=1.8e-7
MP_FA01_X0_IB FA01_X0_bb b01 vdd vdd PM W='2.3999999999999999e-06*WS0' L=1.8e-7
MN_FA01_X0_00A p01 FA01_X0_ab FA01_X0_n00 0 NM W='1.7999999999999999e-06*WS1' L=1.8e-7
MN_FA01_X0_00B FA01_X0_n00 FA01_X0_bb 0 0 NM W='1.7999999999999999e-06*WS1' L=1.8e-7
MN_FA01_X0_11A p01 a01 FA01_X0_n11 0 NM W='1.7999999999999999e-06*WS1' L=1.8e-7
MN_FA01_X0_11B FA01_X0_n11 b01 0 0 NM W='1.7999999999999999e-06*WS1' L=1.8e-7
MP_FA01_X0_01A p01 a01 FA01_X0_p01 vdd PM W='3.5999999999999998e-06*WS1' L=1.8e-7
MP_FA01_X0_01B FA01_X0_p01 FA01_X0_bb vdd vdd PM W='3.5999999999999998e-06*WS1' L=1.8e-7
MP_FA01_X0_10A p01 FA01_X0_ab FA01_X0_p10 vdd PM W='3.5999999999999998e-06*WS1' L=1.8e-7
MP_FA01_X0_10B FA01_X0_p10 b01 vdd vdd PM W='3.5999999999999998e-06*WS1' L=1.8e-7
MN_FA01_X1_IA FA01_X1_ab p01 0 0 NM W='1.1999999999999999e-06*WS0' L=1.8e-7
MP_FA01_X1_IA FA01_X1_ab p01 vdd vdd PM W='2.3999999999999999e-06*WS0' L=1.8e-7
MN_FA01_X1_IB FA01_X1_bb c01 0 0 NM W='1.1999999999999999e-06*WS0' L=1.8e-7
MP_FA01_X1_IB FA01_X1_bb c01 vdd vdd PM W='2.3999999999999999e-06*WS0' L=1.8e-7
MN_FA01_X1_00A sum01 FA01_X1_ab FA01_X1_n00 0 NM W='1.7999999999999999e-06*WS1' L=1.8e-7
MN_FA01_X1_00B FA01_X1_n00 FA01_X1_bb 0 0 NM W='1.7999999999999999e-06*WS1' L=1.8e-7
MN_FA01_X1_11A sum01 p01 FA01_X1_n11 0 NM W='1.7999999999999999e-06*WS1' L=1.8e-7
MN_FA01_X1_11B FA01_X1_n11 c01 0 0 NM W='1.7999999999999999e-06*WS1' L=1.8e-7
MP_FA01_X1_01A sum01 p01 FA01_X1_p01 vdd PM W='3.5999999999999998e-06*WS1' L=1.8e-7
MP_FA01_X1_01B FA01_X1_p01 FA01_X1_bb vdd vdd PM W='3.5999999999999998e-06*WS1' L=1.8e-7
MP_FA01_X1_10A sum01 FA01_X1_ab FA01_X1_p10 vdd PM W='3.5999999999999998e-06*WS1' L=1.8e-7
MP_FA01_X1_10B FA01_X1_p10 c01 vdd vdd PM W='3.5999999999999998e-06*WS1' L=1.8e-7
MN_FA01_NAB_A nab01 a01 FA01_NAB_mid 0 NM W='2.3999999999999999e-06*WS2' L=1.8e-7
MN_FA01_NAB_B FA01_NAB_mid b01 0 0 NM W='2.3999999999999999e-06*WS2' L=1.8e-7
MP_FA01_NAB_A nab01 a01 vdd vdd PM W='4.7999999999999998e-06*WS2' L=1.8e-7
MP_FA01_NAB_B nab01 b01 vdd vdd PM W='4.7999999999999998e-06*WS2' L=1.8e-7
MN_FA01_NPC_A npc01 p01 FA01_NPC_mid 0 NM W='2.3999999999999999e-06*WS2' L=1.8e-7
MN_FA01_NPC_B FA01_NPC_mid c01 0 0 NM W='2.3999999999999999e-06*WS2' L=1.8e-7
MP_FA01_NPC_A npc01 p01 vdd vdd PM W='4.7999999999999998e-06*WS2' L=1.8e-7
MP_FA01_NPC_B npc01 c01 vdd vdd PM W='4.7999999999999998e-06*WS2' L=1.8e-7
MN_FA01_COUT_A c02 nab01 FA01_COUT_mid 0 NM W='7.9999999999999996e-06*WS3' L=1.8e-7
MN_FA01_COUT_B FA01_COUT_mid npc01 0 0 NM W='7.9999999999999996e-06*WS3' L=1.8e-7
MP_FA01_COUT_A c02 nab01 vdd vdd PM W='1.5999999999999999e-05*WS3' L=1.8e-7
MP_FA01_COUT_B c02 npc01 vdd vdd PM W='1.5999999999999999e-05*WS3' L=1.8e-7
MN_FA02_X0_IA FA02_X0_ab a02 0 0 NM W='1.1999999999999999e-06*WS0' L=1.8e-7
MP_FA02_X0_IA FA02_X0_ab a02 vdd vdd PM W='2.3999999999999999e-06*WS0' L=1.8e-7
MN_FA02_X0_IB FA02_X0_bb b02 0 0 NM W='1.1999999999999999e-06*WS0' L=1.8e-7
MP_FA02_X0_IB FA02_X0_bb b02 vdd vdd PM W='2.3999999999999999e-06*WS0' L=1.8e-7
MN_FA02_X0_00A p02 FA02_X0_ab FA02_X0_n00 0 NM W='1.7999999999999999e-06*WS1' L=1.8e-7
MN_FA02_X0_00B FA02_X0_n00 FA02_X0_bb 0 0 NM W='1.7999999999999999e-06*WS1' L=1.8e-7
MN_FA02_X0_11A p02 a02 FA02_X0_n11 0 NM W='1.7999999999999999e-06*WS1' L=1.8e-7
MN_FA02_X0_11B FA02_X0_n11 b02 0 0 NM W='1.7999999999999999e-06*WS1' L=1.8e-7
MP_FA02_X0_01A p02 a02 FA02_X0_p01 vdd PM W='3.5999999999999998e-06*WS1' L=1.8e-7
MP_FA02_X0_01B FA02_X0_p01 FA02_X0_bb vdd vdd PM W='3.5999999999999998e-06*WS1' L=1.8e-7
MP_FA02_X0_10A p02 FA02_X0_ab FA02_X0_p10 vdd PM W='3.5999999999999998e-06*WS1' L=1.8e-7
MP_FA02_X0_10B FA02_X0_p10 b02 vdd vdd PM W='3.5999999999999998e-06*WS1' L=1.8e-7
MN_FA02_X1_IA FA02_X1_ab p02 0 0 NM W='1.1999999999999999e-06*WS0' L=1.8e-7
MP_FA02_X1_IA FA02_X1_ab p02 vdd vdd PM W='2.3999999999999999e-06*WS0' L=1.8e-7
MN_FA02_X1_IB FA02_X1_bb c02 0 0 NM W='1.1999999999999999e-06*WS0' L=1.8e-7
MP_FA02_X1_IB FA02_X1_bb c02 vdd vdd PM W='2.3999999999999999e-06*WS0' L=1.8e-7
MN_FA02_X1_00A sum02 FA02_X1_ab FA02_X1_n00 0 NM W='1.7999999999999999e-06*WS1' L=1.8e-7
MN_FA02_X1_00B FA02_X1_n00 FA02_X1_bb 0 0 NM W='1.7999999999999999e-06*WS1' L=1.8e-7
MN_FA02_X1_11A sum02 p02 FA02_X1_n11 0 NM W='1.7999999999999999e-06*WS1' L=1.8e-7
MN_FA02_X1_11B FA02_X1_n11 c02 0 0 NM W='1.7999999999999999e-06*WS1' L=1.8e-7
MP_FA02_X1_01A sum02 p02 FA02_X1_p01 vdd PM W='3.5999999999999998e-06*WS1' L=1.8e-7
MP_FA02_X1_01B FA02_X1_p01 FA02_X1_bb vdd vdd PM W='3.5999999999999998e-06*WS1' L=1.8e-7
MP_FA02_X1_10A sum02 FA02_X1_ab FA02_X1_p10 vdd PM W='3.5999999999999998e-06*WS1' L=1.8e-7
MP_FA02_X1_10B FA02_X1_p10 c02 vdd vdd PM W='3.5999999999999998e-06*WS1' L=1.8e-7
MN_FA02_NAB_A nab02 a02 FA02_NAB_mid 0 NM W='2.3999999999999999e-06*WS2' L=1.8e-7
MN_FA02_NAB_B FA02_NAB_mid b02 0 0 NM W='2.3999999999999999e-06*WS2' L=1.8e-7
MP_FA02_NAB_A nab02 a02 vdd vdd PM W='4.7999999999999998e-06*WS2' L=1.8e-7
MP_FA02_NAB_B nab02 b02 vdd vdd PM W='4.7999999999999998e-06*WS2' L=1.8e-7
MN_FA02_NPC_A npc02 p02 FA02_NPC_mid 0 NM W='2.3999999999999999e-06*WS2' L=1.8e-7
MN_FA02_NPC_B FA02_NPC_mid c02 0 0 NM W='2.3999999999999999e-06*WS2' L=1.8e-7
MP_FA02_NPC_A npc02 p02 vdd vdd PM W='4.7999999999999998e-06*WS2' L=1.8e-7
MP_FA02_NPC_B npc02 c02 vdd vdd PM W='4.7999999999999998e-06*WS2' L=1.8e-7
MN_FA02_COUT_A c03 nab02 FA02_COUT_mid 0 NM W='7.9999999999999996e-06*WS3' L=1.8e-7
MN_FA02_COUT_B FA02_COUT_mid npc02 0 0 NM W='7.9999999999999996e-06*WS3' L=1.8e-7
MP_FA02_COUT_A c03 nab02 vdd vdd PM W='1.5999999999999999e-05*WS3' L=1.8e-7
MP_FA02_COUT_B c03 npc02 vdd vdd PM W='1.5999999999999999e-05*WS3' L=1.8e-7
MN_FA03_X0_IA FA03_X0_ab a03 0 0 NM W='1.1999999999999999e-06*WS0' L=1.8e-7
MP_FA03_X0_IA FA03_X0_ab a03 vdd vdd PM W='2.3999999999999999e-06*WS0' L=1.8e-7
MN_FA03_X0_IB FA03_X0_bb b03 0 0 NM W='1.1999999999999999e-06*WS0' L=1.8e-7
MP_FA03_X0_IB FA03_X0_bb b03 vdd vdd PM W='2.3999999999999999e-06*WS0' L=1.8e-7
MN_FA03_X0_00A p03 FA03_X0_ab FA03_X0_n00 0 NM W='1.7999999999999999e-06*WS1' L=1.8e-7
MN_FA03_X0_00B FA03_X0_n00 FA03_X0_bb 0 0 NM W='1.7999999999999999e-06*WS1' L=1.8e-7
MN_FA03_X0_11A p03 a03 FA03_X0_n11 0 NM W='1.7999999999999999e-06*WS1' L=1.8e-7
MN_FA03_X0_11B FA03_X0_n11 b03 0 0 NM W='1.7999999999999999e-06*WS1' L=1.8e-7
MP_FA03_X0_01A p03 a03 FA03_X0_p01 vdd PM W='3.5999999999999998e-06*WS1' L=1.8e-7
MP_FA03_X0_01B FA03_X0_p01 FA03_X0_bb vdd vdd PM W='3.5999999999999998e-06*WS1' L=1.8e-7
MP_FA03_X0_10A p03 FA03_X0_ab FA03_X0_p10 vdd PM W='3.5999999999999998e-06*WS1' L=1.8e-7
MP_FA03_X0_10B FA03_X0_p10 b03 vdd vdd PM W='3.5999999999999998e-06*WS1' L=1.8e-7
MN_FA03_X1_IA FA03_X1_ab p03 0 0 NM W='1.1999999999999999e-06*WS0' L=1.8e-7
MP_FA03_X1_IA FA03_X1_ab p03 vdd vdd PM W='2.3999999999999999e-06*WS0' L=1.8e-7
MN_FA03_X1_IB FA03_X1_bb c03 0 0 NM W='1.1999999999999999e-06*WS0' L=1.8e-7
MP_FA03_X1_IB FA03_X1_bb c03 vdd vdd PM W='2.3999999999999999e-06*WS0' L=1.8e-7
MN_FA03_X1_00A sum03 FA03_X1_ab FA03_X1_n00 0 NM W='1.7999999999999999e-06*WS1' L=1.8e-7
MN_FA03_X1_00B FA03_X1_n00 FA03_X1_bb 0 0 NM W='1.7999999999999999e-06*WS1' L=1.8e-7
MN_FA03_X1_11A sum03 p03 FA03_X1_n11 0 NM W='1.7999999999999999e-06*WS1' L=1.8e-7
MN_FA03_X1_11B FA03_X1_n11 c03 0 0 NM W='1.7999999999999999e-06*WS1' L=1.8e-7
MP_FA03_X1_01A sum03 p03 FA03_X1_p01 vdd PM W='3.5999999999999998e-06*WS1' L=1.8e-7
MP_FA03_X1_01B FA03_X1_p01 FA03_X1_bb vdd vdd PM W='3.5999999999999998e-06*WS1' L=1.8e-7
MP_FA03_X1_10A sum03 FA03_X1_ab FA03_X1_p10 vdd PM W='3.5999999999999998e-06*WS1' L=1.8e-7
MP_FA03_X1_10B FA03_X1_p10 c03 vdd vdd PM W='3.5999999999999998e-06*WS1' L=1.8e-7
MN_FA03_NAB_A nab03 a03 FA03_NAB_mid 0 NM W='2.3999999999999999e-06*WS2' L=1.8e-7
MN_FA03_NAB_B FA03_NAB_mid b03 0 0 NM W='2.3999999999999999e-06*WS2' L=1.8e-7
MP_FA03_NAB_A nab03 a03 vdd vdd PM W='4.7999999999999998e-06*WS2' L=1.8e-7
MP_FA03_NAB_B nab03 b03 vdd vdd PM W='4.7999999999999998e-06*WS2' L=1.8e-7
MN_FA03_NPC_A npc03 p03 FA03_NPC_mid 0 NM W='2.3999999999999999e-06*WS2' L=1.8e-7
MN_FA03_NPC_B FA03_NPC_mid c03 0 0 NM W='2.3999999999999999e-06*WS2' L=1.8e-7
MP_FA03_NPC_A npc03 p03 vdd vdd PM W='4.7999999999999998e-06*WS2' L=1.8e-7
MP_FA03_NPC_B npc03 c03 vdd vdd PM W='4.7999999999999998e-06*WS2' L=1.8e-7
MN_FA03_COUT_A c04 nab03 FA03_COUT_mid 0 NM W='7.9999999999999996e-06*WS3' L=1.8e-7
MN_FA03_COUT_B FA03_COUT_mid npc03 0 0 NM W='7.9999999999999996e-06*WS3' L=1.8e-7
MP_FA03_COUT_A c04 nab03 vdd vdd PM W='1.5999999999999999e-05*WS3' L=1.8e-7
MP_FA03_COUT_B c04 npc03 vdd vdd PM W='1.5999999999999999e-05*WS3' L=1.8e-7
MN_FA04_X0_IA FA04_X0_ab a04 0 0 NM W='1.1999999999999999e-06*WS0' L=1.8e-7
MP_FA04_X0_IA FA04_X0_ab a04 vdd vdd PM W='2.3999999999999999e-06*WS0' L=1.8e-7
MN_FA04_X0_IB FA04_X0_bb b04 0 0 NM W='1.1999999999999999e-06*WS0' L=1.8e-7
MP_FA04_X0_IB FA04_X0_bb b04 vdd vdd PM W='2.3999999999999999e-06*WS0' L=1.8e-7
MN_FA04_X0_00A p04 FA04_X0_ab FA04_X0_n00 0 NM W='1.7999999999999999e-06*WS1' L=1.8e-7
MN_FA04_X0_00B FA04_X0_n00 FA04_X0_bb 0 0 NM W='1.7999999999999999e-06*WS1' L=1.8e-7
MN_FA04_X0_11A p04 a04 FA04_X0_n11 0 NM W='1.7999999999999999e-06*WS1' L=1.8e-7
MN_FA04_X0_11B FA04_X0_n11 b04 0 0 NM W='1.7999999999999999e-06*WS1' L=1.8e-7
MP_FA04_X0_01A p04 a04 FA04_X0_p01 vdd PM W='3.5999999999999998e-06*WS1' L=1.8e-7
MP_FA04_X0_01B FA04_X0_p01 FA04_X0_bb vdd vdd PM W='3.5999999999999998e-06*WS1' L=1.8e-7
MP_FA04_X0_10A p04 FA04_X0_ab FA04_X0_p10 vdd PM W='3.5999999999999998e-06*WS1' L=1.8e-7
MP_FA04_X0_10B FA04_X0_p10 b04 vdd vdd PM W='3.5999999999999998e-06*WS1' L=1.8e-7
MN_FA04_X1_IA FA04_X1_ab p04 0 0 NM W='1.1999999999999999e-06*WS0' L=1.8e-7
MP_FA04_X1_IA FA04_X1_ab p04 vdd vdd PM W='2.3999999999999999e-06*WS0' L=1.8e-7
MN_FA04_X1_IB FA04_X1_bb c04 0 0 NM W='1.1999999999999999e-06*WS0' L=1.8e-7
MP_FA04_X1_IB FA04_X1_bb c04 vdd vdd PM W='2.3999999999999999e-06*WS0' L=1.8e-7
MN_FA04_X1_00A sum04 FA04_X1_ab FA04_X1_n00 0 NM W='1.7999999999999999e-06*WS1' L=1.8e-7
MN_FA04_X1_00B FA04_X1_n00 FA04_X1_bb 0 0 NM W='1.7999999999999999e-06*WS1' L=1.8e-7
MN_FA04_X1_11A sum04 p04 FA04_X1_n11 0 NM W='1.7999999999999999e-06*WS1' L=1.8e-7
MN_FA04_X1_11B FA04_X1_n11 c04 0 0 NM W='1.7999999999999999e-06*WS1' L=1.8e-7
MP_FA04_X1_01A sum04 p04 FA04_X1_p01 vdd PM W='3.5999999999999998e-06*WS1' L=1.8e-7
MP_FA04_X1_01B FA04_X1_p01 FA04_X1_bb vdd vdd PM W='3.5999999999999998e-06*WS1' L=1.8e-7
MP_FA04_X1_10A sum04 FA04_X1_ab FA04_X1_p10 vdd PM W='3.5999999999999998e-06*WS1' L=1.8e-7
MP_FA04_X1_10B FA04_X1_p10 c04 vdd vdd PM W='3.5999999999999998e-06*WS1' L=1.8e-7
MN_FA04_NAB_A nab04 a04 FA04_NAB_mid 0 NM W='2.3999999999999999e-06*WS2' L=1.8e-7
MN_FA04_NAB_B FA04_NAB_mid b04 0 0 NM W='2.3999999999999999e-06*WS2' L=1.8e-7
MP_FA04_NAB_A nab04 a04 vdd vdd PM W='4.7999999999999998e-06*WS2' L=1.8e-7
MP_FA04_NAB_B nab04 b04 vdd vdd PM W='4.7999999999999998e-06*WS2' L=1.8e-7
MN_FA04_NPC_A npc04 p04 FA04_NPC_mid 0 NM W='2.3999999999999999e-06*WS2' L=1.8e-7
MN_FA04_NPC_B FA04_NPC_mid c04 0 0 NM W='2.3999999999999999e-06*WS2' L=1.8e-7
MP_FA04_NPC_A npc04 p04 vdd vdd PM W='4.7999999999999998e-06*WS2' L=1.8e-7
MP_FA04_NPC_B npc04 c04 vdd vdd PM W='4.7999999999999998e-06*WS2' L=1.8e-7
MN_FA04_COUT_A c05 nab04 FA04_COUT_mid 0 NM W='7.9999999999999996e-06*WS3' L=1.8e-7
MN_FA04_COUT_B FA04_COUT_mid npc04 0 0 NM W='7.9999999999999996e-06*WS3' L=1.8e-7
MP_FA04_COUT_A c05 nab04 vdd vdd PM W='1.5999999999999999e-05*WS3' L=1.8e-7
MP_FA04_COUT_B c05 npc04 vdd vdd PM W='1.5999999999999999e-05*WS3' L=1.8e-7
MN_FA05_X0_IA FA05_X0_ab a05 0 0 NM W='1.1999999999999999e-06*WS0' L=1.8e-7
MP_FA05_X0_IA FA05_X0_ab a05 vdd vdd PM W='2.3999999999999999e-06*WS0' L=1.8e-7
MN_FA05_X0_IB FA05_X0_bb b05 0 0 NM W='1.1999999999999999e-06*WS0' L=1.8e-7
MP_FA05_X0_IB FA05_X0_bb b05 vdd vdd PM W='2.3999999999999999e-06*WS0' L=1.8e-7
MN_FA05_X0_00A p05 FA05_X0_ab FA05_X0_n00 0 NM W='1.7999999999999999e-06*WS1' L=1.8e-7
MN_FA05_X0_00B FA05_X0_n00 FA05_X0_bb 0 0 NM W='1.7999999999999999e-06*WS1' L=1.8e-7
MN_FA05_X0_11A p05 a05 FA05_X0_n11 0 NM W='1.7999999999999999e-06*WS1' L=1.8e-7
MN_FA05_X0_11B FA05_X0_n11 b05 0 0 NM W='1.7999999999999999e-06*WS1' L=1.8e-7
MP_FA05_X0_01A p05 a05 FA05_X0_p01 vdd PM W='3.5999999999999998e-06*WS1' L=1.8e-7
MP_FA05_X0_01B FA05_X0_p01 FA05_X0_bb vdd vdd PM W='3.5999999999999998e-06*WS1' L=1.8e-7
MP_FA05_X0_10A p05 FA05_X0_ab FA05_X0_p10 vdd PM W='3.5999999999999998e-06*WS1' L=1.8e-7
MP_FA05_X0_10B FA05_X0_p10 b05 vdd vdd PM W='3.5999999999999998e-06*WS1' L=1.8e-7
MN_FA05_X1_IA FA05_X1_ab p05 0 0 NM W='1.1999999999999999e-06*WS0' L=1.8e-7
MP_FA05_X1_IA FA05_X1_ab p05 vdd vdd PM W='2.3999999999999999e-06*WS0' L=1.8e-7
MN_FA05_X1_IB FA05_X1_bb c05 0 0 NM W='1.1999999999999999e-06*WS0' L=1.8e-7
MP_FA05_X1_IB FA05_X1_bb c05 vdd vdd PM W='2.3999999999999999e-06*WS0' L=1.8e-7
MN_FA05_X1_00A sum05 FA05_X1_ab FA05_X1_n00 0 NM W='1.7999999999999999e-06*WS1' L=1.8e-7
MN_FA05_X1_00B FA05_X1_n00 FA05_X1_bb 0 0 NM W='1.7999999999999999e-06*WS1' L=1.8e-7
MN_FA05_X1_11A sum05 p05 FA05_X1_n11 0 NM W='1.7999999999999999e-06*WS1' L=1.8e-7
MN_FA05_X1_11B FA05_X1_n11 c05 0 0 NM W='1.7999999999999999e-06*WS1' L=1.8e-7
MP_FA05_X1_01A sum05 p05 FA05_X1_p01 vdd PM W='3.5999999999999998e-06*WS1' L=1.8e-7
MP_FA05_X1_01B FA05_X1_p01 FA05_X1_bb vdd vdd PM W='3.5999999999999998e-06*WS1' L=1.8e-7
MP_FA05_X1_10A sum05 FA05_X1_ab FA05_X1_p10 vdd PM W='3.5999999999999998e-06*WS1' L=1.8e-7
MP_FA05_X1_10B FA05_X1_p10 c05 vdd vdd PM W='3.5999999999999998e-06*WS1' L=1.8e-7
MN_FA05_NAB_A nab05 a05 FA05_NAB_mid 0 NM W='2.3999999999999999e-06*WS2' L=1.8e-7
MN_FA05_NAB_B FA05_NAB_mid b05 0 0 NM W='2.3999999999999999e-06*WS2' L=1.8e-7
MP_FA05_NAB_A nab05 a05 vdd vdd PM W='4.7999999999999998e-06*WS2' L=1.8e-7
MP_FA05_NAB_B nab05 b05 vdd vdd PM W='4.7999999999999998e-06*WS2' L=1.8e-7
MN_FA05_NPC_A npc05 p05 FA05_NPC_mid 0 NM W='2.3999999999999999e-06*WS2' L=1.8e-7
MN_FA05_NPC_B FA05_NPC_mid c05 0 0 NM W='2.3999999999999999e-06*WS2' L=1.8e-7
MP_FA05_NPC_A npc05 p05 vdd vdd PM W='4.7999999999999998e-06*WS2' L=1.8e-7
MP_FA05_NPC_B npc05 c05 vdd vdd PM W='4.7999999999999998e-06*WS2' L=1.8e-7
MN_FA05_COUT_A c06 nab05 FA05_COUT_mid 0 NM W='7.9999999999999996e-06*WS3' L=1.8e-7
MN_FA05_COUT_B FA05_COUT_mid npc05 0 0 NM W='7.9999999999999996e-06*WS3' L=1.8e-7
MP_FA05_COUT_A c06 nab05 vdd vdd PM W='1.5999999999999999e-05*WS3' L=1.8e-7
MP_FA05_COUT_B c06 npc05 vdd vdd PM W='1.5999999999999999e-05*WS3' L=1.8e-7
MN_FA06_X0_IA FA06_X0_ab a06 0 0 NM W='1.1999999999999999e-06*WS0' L=1.8e-7
MP_FA06_X0_IA FA06_X0_ab a06 vdd vdd PM W='2.3999999999999999e-06*WS0' L=1.8e-7
MN_FA06_X0_IB FA06_X0_bb b06 0 0 NM W='1.1999999999999999e-06*WS0' L=1.8e-7
MP_FA06_X0_IB FA06_X0_bb b06 vdd vdd PM W='2.3999999999999999e-06*WS0' L=1.8e-7
MN_FA06_X0_00A p06 FA06_X0_ab FA06_X0_n00 0 NM W='1.7999999999999999e-06*WS1' L=1.8e-7
MN_FA06_X0_00B FA06_X0_n00 FA06_X0_bb 0 0 NM W='1.7999999999999999e-06*WS1' L=1.8e-7
MN_FA06_X0_11A p06 a06 FA06_X0_n11 0 NM W='1.7999999999999999e-06*WS1' L=1.8e-7
MN_FA06_X0_11B FA06_X0_n11 b06 0 0 NM W='1.7999999999999999e-06*WS1' L=1.8e-7
MP_FA06_X0_01A p06 a06 FA06_X0_p01 vdd PM W='3.5999999999999998e-06*WS1' L=1.8e-7
MP_FA06_X0_01B FA06_X0_p01 FA06_X0_bb vdd vdd PM W='3.5999999999999998e-06*WS1' L=1.8e-7
MP_FA06_X0_10A p06 FA06_X0_ab FA06_X0_p10 vdd PM W='3.5999999999999998e-06*WS1' L=1.8e-7
MP_FA06_X0_10B FA06_X0_p10 b06 vdd vdd PM W='3.5999999999999998e-06*WS1' L=1.8e-7
MN_FA06_X1_IA FA06_X1_ab p06 0 0 NM W='1.1999999999999999e-06*WS0' L=1.8e-7
MP_FA06_X1_IA FA06_X1_ab p06 vdd vdd PM W='2.3999999999999999e-06*WS0' L=1.8e-7
MN_FA06_X1_IB FA06_X1_bb c06 0 0 NM W='1.1999999999999999e-06*WS0' L=1.8e-7
MP_FA06_X1_IB FA06_X1_bb c06 vdd vdd PM W='2.3999999999999999e-06*WS0' L=1.8e-7
MN_FA06_X1_00A sum06 FA06_X1_ab FA06_X1_n00 0 NM W='1.7999999999999999e-06*WS1' L=1.8e-7
MN_FA06_X1_00B FA06_X1_n00 FA06_X1_bb 0 0 NM W='1.7999999999999999e-06*WS1' L=1.8e-7
MN_FA06_X1_11A sum06 p06 FA06_X1_n11 0 NM W='1.7999999999999999e-06*WS1' L=1.8e-7
MN_FA06_X1_11B FA06_X1_n11 c06 0 0 NM W='1.7999999999999999e-06*WS1' L=1.8e-7
MP_FA06_X1_01A sum06 p06 FA06_X1_p01 vdd PM W='3.5999999999999998e-06*WS1' L=1.8e-7
MP_FA06_X1_01B FA06_X1_p01 FA06_X1_bb vdd vdd PM W='3.5999999999999998e-06*WS1' L=1.8e-7
MP_FA06_X1_10A sum06 FA06_X1_ab FA06_X1_p10 vdd PM W='3.5999999999999998e-06*WS1' L=1.8e-7
MP_FA06_X1_10B FA06_X1_p10 c06 vdd vdd PM W='3.5999999999999998e-06*WS1' L=1.8e-7
MN_FA06_NAB_A nab06 a06 FA06_NAB_mid 0 NM W='2.3999999999999999e-06*WS2' L=1.8e-7
MN_FA06_NAB_B FA06_NAB_mid b06 0 0 NM W='2.3999999999999999e-06*WS2' L=1.8e-7
MP_FA06_NAB_A nab06 a06 vdd vdd PM W='4.7999999999999998e-06*WS2' L=1.8e-7
MP_FA06_NAB_B nab06 b06 vdd vdd PM W='4.7999999999999998e-06*WS2' L=1.8e-7
MN_FA06_NPC_A npc06 p06 FA06_NPC_mid 0 NM W='2.3999999999999999e-06*WS2' L=1.8e-7
MN_FA06_NPC_B FA06_NPC_mid c06 0 0 NM W='2.3999999999999999e-06*WS2' L=1.8e-7
MP_FA06_NPC_A npc06 p06 vdd vdd PM W='4.7999999999999998e-06*WS2' L=1.8e-7
MP_FA06_NPC_B npc06 c06 vdd vdd PM W='4.7999999999999998e-06*WS2' L=1.8e-7
MN_FA06_COUT_A c07 nab06 FA06_COUT_mid 0 NM W='7.9999999999999996e-06*WS3' L=1.8e-7
MN_FA06_COUT_B FA06_COUT_mid npc06 0 0 NM W='7.9999999999999996e-06*WS3' L=1.8e-7
MP_FA06_COUT_A c07 nab06 vdd vdd PM W='1.5999999999999999e-05*WS3' L=1.8e-7
MP_FA06_COUT_B c07 npc06 vdd vdd PM W='1.5999999999999999e-05*WS3' L=1.8e-7
MN_FA07_X0_IA FA07_X0_ab a07 0 0 NM W='1.1999999999999999e-06*WS0' L=1.8e-7
MP_FA07_X0_IA FA07_X0_ab a07 vdd vdd PM W='2.3999999999999999e-06*WS0' L=1.8e-7
MN_FA07_X0_IB FA07_X0_bb b07 0 0 NM W='1.1999999999999999e-06*WS0' L=1.8e-7
MP_FA07_X0_IB FA07_X0_bb b07 vdd vdd PM W='2.3999999999999999e-06*WS0' L=1.8e-7
MN_FA07_X0_00A p07 FA07_X0_ab FA07_X0_n00 0 NM W='1.7999999999999999e-06*WS1' L=1.8e-7
MN_FA07_X0_00B FA07_X0_n00 FA07_X0_bb 0 0 NM W='1.7999999999999999e-06*WS1' L=1.8e-7
MN_FA07_X0_11A p07 a07 FA07_X0_n11 0 NM W='1.7999999999999999e-06*WS1' L=1.8e-7
MN_FA07_X0_11B FA07_X0_n11 b07 0 0 NM W='1.7999999999999999e-06*WS1' L=1.8e-7
MP_FA07_X0_01A p07 a07 FA07_X0_p01 vdd PM W='3.5999999999999998e-06*WS1' L=1.8e-7
MP_FA07_X0_01B FA07_X0_p01 FA07_X0_bb vdd vdd PM W='3.5999999999999998e-06*WS1' L=1.8e-7
MP_FA07_X0_10A p07 FA07_X0_ab FA07_X0_p10 vdd PM W='3.5999999999999998e-06*WS1' L=1.8e-7
MP_FA07_X0_10B FA07_X0_p10 b07 vdd vdd PM W='3.5999999999999998e-06*WS1' L=1.8e-7
MN_FA07_X1_IA FA07_X1_ab p07 0 0 NM W='1.1999999999999999e-06*WS0' L=1.8e-7
MP_FA07_X1_IA FA07_X1_ab p07 vdd vdd PM W='2.3999999999999999e-06*WS0' L=1.8e-7
MN_FA07_X1_IB FA07_X1_bb c07 0 0 NM W='1.1999999999999999e-06*WS0' L=1.8e-7
MP_FA07_X1_IB FA07_X1_bb c07 vdd vdd PM W='2.3999999999999999e-06*WS0' L=1.8e-7
MN_FA07_X1_00A sum07 FA07_X1_ab FA07_X1_n00 0 NM W='1.7999999999999999e-06*WS1' L=1.8e-7
MN_FA07_X1_00B FA07_X1_n00 FA07_X1_bb 0 0 NM W='1.7999999999999999e-06*WS1' L=1.8e-7
MN_FA07_X1_11A sum07 p07 FA07_X1_n11 0 NM W='1.7999999999999999e-06*WS1' L=1.8e-7
MN_FA07_X1_11B FA07_X1_n11 c07 0 0 NM W='1.7999999999999999e-06*WS1' L=1.8e-7
MP_FA07_X1_01A sum07 p07 FA07_X1_p01 vdd PM W='3.5999999999999998e-06*WS1' L=1.8e-7
MP_FA07_X1_01B FA07_X1_p01 FA07_X1_bb vdd vdd PM W='3.5999999999999998e-06*WS1' L=1.8e-7
MP_FA07_X1_10A sum07 FA07_X1_ab FA07_X1_p10 vdd PM W='3.5999999999999998e-06*WS1' L=1.8e-7
MP_FA07_X1_10B FA07_X1_p10 c07 vdd vdd PM W='3.5999999999999998e-06*WS1' L=1.8e-7
MN_FA07_NAB_A nab07 a07 FA07_NAB_mid 0 NM W='2.3999999999999999e-06*WS2' L=1.8e-7
MN_FA07_NAB_B FA07_NAB_mid b07 0 0 NM W='2.3999999999999999e-06*WS2' L=1.8e-7
MP_FA07_NAB_A nab07 a07 vdd vdd PM W='4.7999999999999998e-06*WS2' L=1.8e-7
MP_FA07_NAB_B nab07 b07 vdd vdd PM W='4.7999999999999998e-06*WS2' L=1.8e-7
MN_FA07_NPC_A npc07 p07 FA07_NPC_mid 0 NM W='2.3999999999999999e-06*WS2' L=1.8e-7
MN_FA07_NPC_B FA07_NPC_mid c07 0 0 NM W='2.3999999999999999e-06*WS2' L=1.8e-7
MP_FA07_NPC_A npc07 p07 vdd vdd PM W='4.7999999999999998e-06*WS2' L=1.8e-7
MP_FA07_NPC_B npc07 c07 vdd vdd PM W='4.7999999999999998e-06*WS2' L=1.8e-7
MN_FA07_COUT_A c08 nab07 FA07_COUT_mid 0 NM W='7.9999999999999996e-06*WS3' L=1.8e-7
MN_FA07_COUT_B FA07_COUT_mid npc07 0 0 NM W='7.9999999999999996e-06*WS3' L=1.8e-7
MP_FA07_COUT_A c08 nab07 vdd vdd PM W='1.5999999999999999e-05*WS3' L=1.8e-7
MP_FA07_COUT_B c08 npc07 vdd vdd PM W='1.5999999999999999e-05*WS3' L=1.8e-7
MN_FA08_X0_IA FA08_X0_ab a08 0 0 NM W='1.1999999999999999e-06*WS0' L=1.8e-7
MP_FA08_X0_IA FA08_X0_ab a08 vdd vdd PM W='2.3999999999999999e-06*WS0' L=1.8e-7
MN_FA08_X0_IB FA08_X0_bb b08 0 0 NM W='1.1999999999999999e-06*WS0' L=1.8e-7
MP_FA08_X0_IB FA08_X0_bb b08 vdd vdd PM W='2.3999999999999999e-06*WS0' L=1.8e-7
MN_FA08_X0_00A p08 FA08_X0_ab FA08_X0_n00 0 NM W='1.7999999999999999e-06*WS1' L=1.8e-7
MN_FA08_X0_00B FA08_X0_n00 FA08_X0_bb 0 0 NM W='1.7999999999999999e-06*WS1' L=1.8e-7
MN_FA08_X0_11A p08 a08 FA08_X0_n11 0 NM W='1.7999999999999999e-06*WS1' L=1.8e-7
MN_FA08_X0_11B FA08_X0_n11 b08 0 0 NM W='1.7999999999999999e-06*WS1' L=1.8e-7
MP_FA08_X0_01A p08 a08 FA08_X0_p01 vdd PM W='3.5999999999999998e-06*WS1' L=1.8e-7
MP_FA08_X0_01B FA08_X0_p01 FA08_X0_bb vdd vdd PM W='3.5999999999999998e-06*WS1' L=1.8e-7
MP_FA08_X0_10A p08 FA08_X0_ab FA08_X0_p10 vdd PM W='3.5999999999999998e-06*WS1' L=1.8e-7
MP_FA08_X0_10B FA08_X0_p10 b08 vdd vdd PM W='3.5999999999999998e-06*WS1' L=1.8e-7
MN_FA08_X1_IA FA08_X1_ab p08 0 0 NM W='1.1999999999999999e-06*WS0' L=1.8e-7
MP_FA08_X1_IA FA08_X1_ab p08 vdd vdd PM W='2.3999999999999999e-06*WS0' L=1.8e-7
MN_FA08_X1_IB FA08_X1_bb c08 0 0 NM W='1.1999999999999999e-06*WS0' L=1.8e-7
MP_FA08_X1_IB FA08_X1_bb c08 vdd vdd PM W='2.3999999999999999e-06*WS0' L=1.8e-7
MN_FA08_X1_00A sum08 FA08_X1_ab FA08_X1_n00 0 NM W='1.7999999999999999e-06*WS1' L=1.8e-7
MN_FA08_X1_00B FA08_X1_n00 FA08_X1_bb 0 0 NM W='1.7999999999999999e-06*WS1' L=1.8e-7
MN_FA08_X1_11A sum08 p08 FA08_X1_n11 0 NM W='1.7999999999999999e-06*WS1' L=1.8e-7
MN_FA08_X1_11B FA08_X1_n11 c08 0 0 NM W='1.7999999999999999e-06*WS1' L=1.8e-7
MP_FA08_X1_01A sum08 p08 FA08_X1_p01 vdd PM W='3.5999999999999998e-06*WS1' L=1.8e-7
MP_FA08_X1_01B FA08_X1_p01 FA08_X1_bb vdd vdd PM W='3.5999999999999998e-06*WS1' L=1.8e-7
MP_FA08_X1_10A sum08 FA08_X1_ab FA08_X1_p10 vdd PM W='3.5999999999999998e-06*WS1' L=1.8e-7
MP_FA08_X1_10B FA08_X1_p10 c08 vdd vdd PM W='3.5999999999999998e-06*WS1' L=1.8e-7
MN_FA08_NAB_A nab08 a08 FA08_NAB_mid 0 NM W='2.3999999999999999e-06*WS2' L=1.8e-7
MN_FA08_NAB_B FA08_NAB_mid b08 0 0 NM W='2.3999999999999999e-06*WS2' L=1.8e-7
MP_FA08_NAB_A nab08 a08 vdd vdd PM W='4.7999999999999998e-06*WS2' L=1.8e-7
MP_FA08_NAB_B nab08 b08 vdd vdd PM W='4.7999999999999998e-06*WS2' L=1.8e-7
MN_FA08_NPC_A npc08 p08 FA08_NPC_mid 0 NM W='2.3999999999999999e-06*WS2' L=1.8e-7
MN_FA08_NPC_B FA08_NPC_mid c08 0 0 NM W='2.3999999999999999e-06*WS2' L=1.8e-7
MP_FA08_NPC_A npc08 p08 vdd vdd PM W='4.7999999999999998e-06*WS2' L=1.8e-7
MP_FA08_NPC_B npc08 c08 vdd vdd PM W='4.7999999999999998e-06*WS2' L=1.8e-7
MN_FA08_COUT_A c09 nab08 FA08_COUT_mid 0 NM W='7.9999999999999996e-06*WS3' L=1.8e-7
MN_FA08_COUT_B FA08_COUT_mid npc08 0 0 NM W='7.9999999999999996e-06*WS3' L=1.8e-7
MP_FA08_COUT_A c09 nab08 vdd vdd PM W='1.5999999999999999e-05*WS3' L=1.8e-7
MP_FA08_COUT_B c09 npc08 vdd vdd PM W='1.5999999999999999e-05*WS3' L=1.8e-7
MN_FA09_X0_IA FA09_X0_ab a09 0 0 NM W='1.1999999999999999e-06*WS0' L=1.8e-7
MP_FA09_X0_IA FA09_X0_ab a09 vdd vdd PM W='2.3999999999999999e-06*WS0' L=1.8e-7
MN_FA09_X0_IB FA09_X0_bb b09 0 0 NM W='1.1999999999999999e-06*WS0' L=1.8e-7
MP_FA09_X0_IB FA09_X0_bb b09 vdd vdd PM W='2.3999999999999999e-06*WS0' L=1.8e-7
MN_FA09_X0_00A p09 FA09_X0_ab FA09_X0_n00 0 NM W='1.7999999999999999e-06*WS1' L=1.8e-7
MN_FA09_X0_00B FA09_X0_n00 FA09_X0_bb 0 0 NM W='1.7999999999999999e-06*WS1' L=1.8e-7
MN_FA09_X0_11A p09 a09 FA09_X0_n11 0 NM W='1.7999999999999999e-06*WS1' L=1.8e-7
MN_FA09_X0_11B FA09_X0_n11 b09 0 0 NM W='1.7999999999999999e-06*WS1' L=1.8e-7
MP_FA09_X0_01A p09 a09 FA09_X0_p01 vdd PM W='3.5999999999999998e-06*WS1' L=1.8e-7
MP_FA09_X0_01B FA09_X0_p01 FA09_X0_bb vdd vdd PM W='3.5999999999999998e-06*WS1' L=1.8e-7
MP_FA09_X0_10A p09 FA09_X0_ab FA09_X0_p10 vdd PM W='3.5999999999999998e-06*WS1' L=1.8e-7
MP_FA09_X0_10B FA09_X0_p10 b09 vdd vdd PM W='3.5999999999999998e-06*WS1' L=1.8e-7
MN_FA09_X1_IA FA09_X1_ab p09 0 0 NM W='1.1999999999999999e-06*WS0' L=1.8e-7
MP_FA09_X1_IA FA09_X1_ab p09 vdd vdd PM W='2.3999999999999999e-06*WS0' L=1.8e-7
MN_FA09_X1_IB FA09_X1_bb c09 0 0 NM W='1.1999999999999999e-06*WS0' L=1.8e-7
MP_FA09_X1_IB FA09_X1_bb c09 vdd vdd PM W='2.3999999999999999e-06*WS0' L=1.8e-7
MN_FA09_X1_00A sum09 FA09_X1_ab FA09_X1_n00 0 NM W='1.7999999999999999e-06*WS1' L=1.8e-7
MN_FA09_X1_00B FA09_X1_n00 FA09_X1_bb 0 0 NM W='1.7999999999999999e-06*WS1' L=1.8e-7
MN_FA09_X1_11A sum09 p09 FA09_X1_n11 0 NM W='1.7999999999999999e-06*WS1' L=1.8e-7
MN_FA09_X1_11B FA09_X1_n11 c09 0 0 NM W='1.7999999999999999e-06*WS1' L=1.8e-7
MP_FA09_X1_01A sum09 p09 FA09_X1_p01 vdd PM W='3.5999999999999998e-06*WS1' L=1.8e-7
MP_FA09_X1_01B FA09_X1_p01 FA09_X1_bb vdd vdd PM W='3.5999999999999998e-06*WS1' L=1.8e-7
MP_FA09_X1_10A sum09 FA09_X1_ab FA09_X1_p10 vdd PM W='3.5999999999999998e-06*WS1' L=1.8e-7
MP_FA09_X1_10B FA09_X1_p10 c09 vdd vdd PM W='3.5999999999999998e-06*WS1' L=1.8e-7
MN_FA09_NAB_A nab09 a09 FA09_NAB_mid 0 NM W='2.3999999999999999e-06*WS2' L=1.8e-7
MN_FA09_NAB_B FA09_NAB_mid b09 0 0 NM W='2.3999999999999999e-06*WS2' L=1.8e-7
MP_FA09_NAB_A nab09 a09 vdd vdd PM W='4.7999999999999998e-06*WS2' L=1.8e-7
MP_FA09_NAB_B nab09 b09 vdd vdd PM W='4.7999999999999998e-06*WS2' L=1.8e-7
MN_FA09_NPC_A npc09 p09 FA09_NPC_mid 0 NM W='2.3999999999999999e-06*WS2' L=1.8e-7
MN_FA09_NPC_B FA09_NPC_mid c09 0 0 NM W='2.3999999999999999e-06*WS2' L=1.8e-7
MP_FA09_NPC_A npc09 p09 vdd vdd PM W='4.7999999999999998e-06*WS2' L=1.8e-7
MP_FA09_NPC_B npc09 c09 vdd vdd PM W='4.7999999999999998e-06*WS2' L=1.8e-7
MN_FA09_COUT_A c10 nab09 FA09_COUT_mid 0 NM W='7.9999999999999996e-06*WS3' L=1.8e-7
MN_FA09_COUT_B FA09_COUT_mid npc09 0 0 NM W='7.9999999999999996e-06*WS3' L=1.8e-7
MP_FA09_COUT_A c10 nab09 vdd vdd PM W='1.5999999999999999e-05*WS3' L=1.8e-7
MP_FA09_COUT_B c10 npc09 vdd vdd PM W='1.5999999999999999e-05*WS3' L=1.8e-7
MN_FA10_X0_IA FA10_X0_ab a10 0 0 NM W='1.1999999999999999e-06*WS0' L=1.8e-7
MP_FA10_X0_IA FA10_X0_ab a10 vdd vdd PM W='2.3999999999999999e-06*WS0' L=1.8e-7
MN_FA10_X0_IB FA10_X0_bb b10 0 0 NM W='1.1999999999999999e-06*WS0' L=1.8e-7
MP_FA10_X0_IB FA10_X0_bb b10 vdd vdd PM W='2.3999999999999999e-06*WS0' L=1.8e-7
MN_FA10_X0_00A p10 FA10_X0_ab FA10_X0_n00 0 NM W='1.7999999999999999e-06*WS1' L=1.8e-7
MN_FA10_X0_00B FA10_X0_n00 FA10_X0_bb 0 0 NM W='1.7999999999999999e-06*WS1' L=1.8e-7
MN_FA10_X0_11A p10 a10 FA10_X0_n11 0 NM W='1.7999999999999999e-06*WS1' L=1.8e-7
MN_FA10_X0_11B FA10_X0_n11 b10 0 0 NM W='1.7999999999999999e-06*WS1' L=1.8e-7
MP_FA10_X0_01A p10 a10 FA10_X0_p01 vdd PM W='3.5999999999999998e-06*WS1' L=1.8e-7
MP_FA10_X0_01B FA10_X0_p01 FA10_X0_bb vdd vdd PM W='3.5999999999999998e-06*WS1' L=1.8e-7
MP_FA10_X0_10A p10 FA10_X0_ab FA10_X0_p10 vdd PM W='3.5999999999999998e-06*WS1' L=1.8e-7
MP_FA10_X0_10B FA10_X0_p10 b10 vdd vdd PM W='3.5999999999999998e-06*WS1' L=1.8e-7
MN_FA10_X1_IA FA10_X1_ab p10 0 0 NM W='1.1999999999999999e-06*WS0' L=1.8e-7
MP_FA10_X1_IA FA10_X1_ab p10 vdd vdd PM W='2.3999999999999999e-06*WS0' L=1.8e-7
MN_FA10_X1_IB FA10_X1_bb c10 0 0 NM W='1.1999999999999999e-06*WS0' L=1.8e-7
MP_FA10_X1_IB FA10_X1_bb c10 vdd vdd PM W='2.3999999999999999e-06*WS0' L=1.8e-7
MN_FA10_X1_00A sum10 FA10_X1_ab FA10_X1_n00 0 NM W='1.7999999999999999e-06*WS1' L=1.8e-7
MN_FA10_X1_00B FA10_X1_n00 FA10_X1_bb 0 0 NM W='1.7999999999999999e-06*WS1' L=1.8e-7
MN_FA10_X1_11A sum10 p10 FA10_X1_n11 0 NM W='1.7999999999999999e-06*WS1' L=1.8e-7
MN_FA10_X1_11B FA10_X1_n11 c10 0 0 NM W='1.7999999999999999e-06*WS1' L=1.8e-7
MP_FA10_X1_01A sum10 p10 FA10_X1_p01 vdd PM W='3.5999999999999998e-06*WS1' L=1.8e-7
MP_FA10_X1_01B FA10_X1_p01 FA10_X1_bb vdd vdd PM W='3.5999999999999998e-06*WS1' L=1.8e-7
MP_FA10_X1_10A sum10 FA10_X1_ab FA10_X1_p10 vdd PM W='3.5999999999999998e-06*WS1' L=1.8e-7
MP_FA10_X1_10B FA10_X1_p10 c10 vdd vdd PM W='3.5999999999999998e-06*WS1' L=1.8e-7
MN_FA10_NAB_A nab10 a10 FA10_NAB_mid 0 NM W='2.3999999999999999e-06*WS2' L=1.8e-7
MN_FA10_NAB_B FA10_NAB_mid b10 0 0 NM W='2.3999999999999999e-06*WS2' L=1.8e-7
MP_FA10_NAB_A nab10 a10 vdd vdd PM W='4.7999999999999998e-06*WS2' L=1.8e-7
MP_FA10_NAB_B nab10 b10 vdd vdd PM W='4.7999999999999998e-06*WS2' L=1.8e-7
MN_FA10_NPC_A npc10 p10 FA10_NPC_mid 0 NM W='2.3999999999999999e-06*WS2' L=1.8e-7
MN_FA10_NPC_B FA10_NPC_mid c10 0 0 NM W='2.3999999999999999e-06*WS2' L=1.8e-7
MP_FA10_NPC_A npc10 p10 vdd vdd PM W='4.7999999999999998e-06*WS2' L=1.8e-7
MP_FA10_NPC_B npc10 c10 vdd vdd PM W='4.7999999999999998e-06*WS2' L=1.8e-7
MN_FA10_COUT_A c11 nab10 FA10_COUT_mid 0 NM W='7.9999999999999996e-06*WS3' L=1.8e-7
MN_FA10_COUT_B FA10_COUT_mid npc10 0 0 NM W='7.9999999999999996e-06*WS3' L=1.8e-7
MP_FA10_COUT_A c11 nab10 vdd vdd PM W='1.5999999999999999e-05*WS3' L=1.8e-7
MP_FA10_COUT_B c11 npc10 vdd vdd PM W='1.5999999999999999e-05*WS3' L=1.8e-7
MN_FA11_X0_IA FA11_X0_ab a11 0 0 NM W='1.1999999999999999e-06*WS0' L=1.8e-7
MP_FA11_X0_IA FA11_X0_ab a11 vdd vdd PM W='2.3999999999999999e-06*WS0' L=1.8e-7
MN_FA11_X0_IB FA11_X0_bb b11 0 0 NM W='1.1999999999999999e-06*WS0' L=1.8e-7
MP_FA11_X0_IB FA11_X0_bb b11 vdd vdd PM W='2.3999999999999999e-06*WS0' L=1.8e-7
MN_FA11_X0_00A p11 FA11_X0_ab FA11_X0_n00 0 NM W='1.7999999999999999e-06*WS1' L=1.8e-7
MN_FA11_X0_00B FA11_X0_n00 FA11_X0_bb 0 0 NM W='1.7999999999999999e-06*WS1' L=1.8e-7
MN_FA11_X0_11A p11 a11 FA11_X0_n11 0 NM W='1.7999999999999999e-06*WS1' L=1.8e-7
MN_FA11_X0_11B FA11_X0_n11 b11 0 0 NM W='1.7999999999999999e-06*WS1' L=1.8e-7
MP_FA11_X0_01A p11 a11 FA11_X0_p01 vdd PM W='3.5999999999999998e-06*WS1' L=1.8e-7
MP_FA11_X0_01B FA11_X0_p01 FA11_X0_bb vdd vdd PM W='3.5999999999999998e-06*WS1' L=1.8e-7
MP_FA11_X0_10A p11 FA11_X0_ab FA11_X0_p10 vdd PM W='3.5999999999999998e-06*WS1' L=1.8e-7
MP_FA11_X0_10B FA11_X0_p10 b11 vdd vdd PM W='3.5999999999999998e-06*WS1' L=1.8e-7
MN_FA11_X1_IA FA11_X1_ab p11 0 0 NM W='1.1999999999999999e-06*WS0' L=1.8e-7
MP_FA11_X1_IA FA11_X1_ab p11 vdd vdd PM W='2.3999999999999999e-06*WS0' L=1.8e-7
MN_FA11_X1_IB FA11_X1_bb c11 0 0 NM W='1.1999999999999999e-06*WS0' L=1.8e-7
MP_FA11_X1_IB FA11_X1_bb c11 vdd vdd PM W='2.3999999999999999e-06*WS0' L=1.8e-7
MN_FA11_X1_00A sum11 FA11_X1_ab FA11_X1_n00 0 NM W='1.7999999999999999e-06*WS1' L=1.8e-7
MN_FA11_X1_00B FA11_X1_n00 FA11_X1_bb 0 0 NM W='1.7999999999999999e-06*WS1' L=1.8e-7
MN_FA11_X1_11A sum11 p11 FA11_X1_n11 0 NM W='1.7999999999999999e-06*WS1' L=1.8e-7
MN_FA11_X1_11B FA11_X1_n11 c11 0 0 NM W='1.7999999999999999e-06*WS1' L=1.8e-7
MP_FA11_X1_01A sum11 p11 FA11_X1_p01 vdd PM W='3.5999999999999998e-06*WS1' L=1.8e-7
MP_FA11_X1_01B FA11_X1_p01 FA11_X1_bb vdd vdd PM W='3.5999999999999998e-06*WS1' L=1.8e-7
MP_FA11_X1_10A sum11 FA11_X1_ab FA11_X1_p10 vdd PM W='3.5999999999999998e-06*WS1' L=1.8e-7
MP_FA11_X1_10B FA11_X1_p10 c11 vdd vdd PM W='3.5999999999999998e-06*WS1' L=1.8e-7
MN_FA11_NAB_A nab11 a11 FA11_NAB_mid 0 NM W='2.3999999999999999e-06*WS2' L=1.8e-7
MN_FA11_NAB_B FA11_NAB_mid b11 0 0 NM W='2.3999999999999999e-06*WS2' L=1.8e-7
MP_FA11_NAB_A nab11 a11 vdd vdd PM W='4.7999999999999998e-06*WS2' L=1.8e-7
MP_FA11_NAB_B nab11 b11 vdd vdd PM W='4.7999999999999998e-06*WS2' L=1.8e-7
MN_FA11_NPC_A npc11 p11 FA11_NPC_mid 0 NM W='2.3999999999999999e-06*WS2' L=1.8e-7
MN_FA11_NPC_B FA11_NPC_mid c11 0 0 NM W='2.3999999999999999e-06*WS2' L=1.8e-7
MP_FA11_NPC_A npc11 p11 vdd vdd PM W='4.7999999999999998e-06*WS2' L=1.8e-7
MP_FA11_NPC_B npc11 c11 vdd vdd PM W='4.7999999999999998e-06*WS2' L=1.8e-7
MN_FA11_COUT_A c12 nab11 FA11_COUT_mid 0 NM W='7.9999999999999996e-06*WS3' L=1.8e-7
MN_FA11_COUT_B FA11_COUT_mid npc11 0 0 NM W='7.9999999999999996e-06*WS3' L=1.8e-7
MP_FA11_COUT_A c12 nab11 vdd vdd PM W='1.5999999999999999e-05*WS3' L=1.8e-7
MP_FA11_COUT_B c12 npc11 vdd vdd PM W='1.5999999999999999e-05*WS3' L=1.8e-7
MN_FA12_X0_IA FA12_X0_ab a12 0 0 NM W='1.1999999999999999e-06*WS0' L=1.8e-7
MP_FA12_X0_IA FA12_X0_ab a12 vdd vdd PM W='2.3999999999999999e-06*WS0' L=1.8e-7
MN_FA12_X0_IB FA12_X0_bb b12 0 0 NM W='1.1999999999999999e-06*WS0' L=1.8e-7
MP_FA12_X0_IB FA12_X0_bb b12 vdd vdd PM W='2.3999999999999999e-06*WS0' L=1.8e-7
MN_FA12_X0_00A p12 FA12_X0_ab FA12_X0_n00 0 NM W='1.7999999999999999e-06*WS1' L=1.8e-7
MN_FA12_X0_00B FA12_X0_n00 FA12_X0_bb 0 0 NM W='1.7999999999999999e-06*WS1' L=1.8e-7
MN_FA12_X0_11A p12 a12 FA12_X0_n11 0 NM W='1.7999999999999999e-06*WS1' L=1.8e-7
MN_FA12_X0_11B FA12_X0_n11 b12 0 0 NM W='1.7999999999999999e-06*WS1' L=1.8e-7
MP_FA12_X0_01A p12 a12 FA12_X0_p01 vdd PM W='3.5999999999999998e-06*WS1' L=1.8e-7
MP_FA12_X0_01B FA12_X0_p01 FA12_X0_bb vdd vdd PM W='3.5999999999999998e-06*WS1' L=1.8e-7
MP_FA12_X0_10A p12 FA12_X0_ab FA12_X0_p10 vdd PM W='3.5999999999999998e-06*WS1' L=1.8e-7
MP_FA12_X0_10B FA12_X0_p10 b12 vdd vdd PM W='3.5999999999999998e-06*WS1' L=1.8e-7
MN_FA12_X1_IA FA12_X1_ab p12 0 0 NM W='1.1999999999999999e-06*WS0' L=1.8e-7
MP_FA12_X1_IA FA12_X1_ab p12 vdd vdd PM W='2.3999999999999999e-06*WS0' L=1.8e-7
MN_FA12_X1_IB FA12_X1_bb c12 0 0 NM W='1.1999999999999999e-06*WS0' L=1.8e-7
MP_FA12_X1_IB FA12_X1_bb c12 vdd vdd PM W='2.3999999999999999e-06*WS0' L=1.8e-7
MN_FA12_X1_00A sum12 FA12_X1_ab FA12_X1_n00 0 NM W='1.7999999999999999e-06*WS1' L=1.8e-7
MN_FA12_X1_00B FA12_X1_n00 FA12_X1_bb 0 0 NM W='1.7999999999999999e-06*WS1' L=1.8e-7
MN_FA12_X1_11A sum12 p12 FA12_X1_n11 0 NM W='1.7999999999999999e-06*WS1' L=1.8e-7
MN_FA12_X1_11B FA12_X1_n11 c12 0 0 NM W='1.7999999999999999e-06*WS1' L=1.8e-7
MP_FA12_X1_01A sum12 p12 FA12_X1_p01 vdd PM W='3.5999999999999998e-06*WS1' L=1.8e-7
MP_FA12_X1_01B FA12_X1_p01 FA12_X1_bb vdd vdd PM W='3.5999999999999998e-06*WS1' L=1.8e-7
MP_FA12_X1_10A sum12 FA12_X1_ab FA12_X1_p10 vdd PM W='3.5999999999999998e-06*WS1' L=1.8e-7
MP_FA12_X1_10B FA12_X1_p10 c12 vdd vdd PM W='3.5999999999999998e-06*WS1' L=1.8e-7
MN_FA12_NAB_A nab12 a12 FA12_NAB_mid 0 NM W='2.3999999999999999e-06*WS2' L=1.8e-7
MN_FA12_NAB_B FA12_NAB_mid b12 0 0 NM W='2.3999999999999999e-06*WS2' L=1.8e-7
MP_FA12_NAB_A nab12 a12 vdd vdd PM W='4.7999999999999998e-06*WS2' L=1.8e-7
MP_FA12_NAB_B nab12 b12 vdd vdd PM W='4.7999999999999998e-06*WS2' L=1.8e-7
MN_FA12_NPC_A npc12 p12 FA12_NPC_mid 0 NM W='2.3999999999999999e-06*WS2' L=1.8e-7
MN_FA12_NPC_B FA12_NPC_mid c12 0 0 NM W='2.3999999999999999e-06*WS2' L=1.8e-7
MP_FA12_NPC_A npc12 p12 vdd vdd PM W='4.7999999999999998e-06*WS2' L=1.8e-7
MP_FA12_NPC_B npc12 c12 vdd vdd PM W='4.7999999999999998e-06*WS2' L=1.8e-7
MN_FA12_COUT_A c13 nab12 FA12_COUT_mid 0 NM W='7.9999999999999996e-06*WS3' L=1.8e-7
MN_FA12_COUT_B FA12_COUT_mid npc12 0 0 NM W='7.9999999999999996e-06*WS3' L=1.8e-7
MP_FA12_COUT_A c13 nab12 vdd vdd PM W='1.5999999999999999e-05*WS3' L=1.8e-7
MP_FA12_COUT_B c13 npc12 vdd vdd PM W='1.5999999999999999e-05*WS3' L=1.8e-7
MN_FA13_X0_IA FA13_X0_ab a13 0 0 NM W='1.1999999999999999e-06*WS0' L=1.8e-7
MP_FA13_X0_IA FA13_X0_ab a13 vdd vdd PM W='2.3999999999999999e-06*WS0' L=1.8e-7
MN_FA13_X0_IB FA13_X0_bb b13 0 0 NM W='1.1999999999999999e-06*WS0' L=1.8e-7
MP_FA13_X0_IB FA13_X0_bb b13 vdd vdd PM W='2.3999999999999999e-06*WS0' L=1.8e-7
MN_FA13_X0_00A p13 FA13_X0_ab FA13_X0_n00 0 NM W='1.7999999999999999e-06*WS1' L=1.8e-7
MN_FA13_X0_00B FA13_X0_n00 FA13_X0_bb 0 0 NM W='1.7999999999999999e-06*WS1' L=1.8e-7
MN_FA13_X0_11A p13 a13 FA13_X0_n11 0 NM W='1.7999999999999999e-06*WS1' L=1.8e-7
MN_FA13_X0_11B FA13_X0_n11 b13 0 0 NM W='1.7999999999999999e-06*WS1' L=1.8e-7
MP_FA13_X0_01A p13 a13 FA13_X0_p01 vdd PM W='3.5999999999999998e-06*WS1' L=1.8e-7
MP_FA13_X0_01B FA13_X0_p01 FA13_X0_bb vdd vdd PM W='3.5999999999999998e-06*WS1' L=1.8e-7
MP_FA13_X0_10A p13 FA13_X0_ab FA13_X0_p10 vdd PM W='3.5999999999999998e-06*WS1' L=1.8e-7
MP_FA13_X0_10B FA13_X0_p10 b13 vdd vdd PM W='3.5999999999999998e-06*WS1' L=1.8e-7
MN_FA13_X1_IA FA13_X1_ab p13 0 0 NM W='1.1999999999999999e-06*WS0' L=1.8e-7
MP_FA13_X1_IA FA13_X1_ab p13 vdd vdd PM W='2.3999999999999999e-06*WS0' L=1.8e-7
MN_FA13_X1_IB FA13_X1_bb c13 0 0 NM W='1.1999999999999999e-06*WS0' L=1.8e-7
MP_FA13_X1_IB FA13_X1_bb c13 vdd vdd PM W='2.3999999999999999e-06*WS0' L=1.8e-7
MN_FA13_X1_00A sum13 FA13_X1_ab FA13_X1_n00 0 NM W='1.7999999999999999e-06*WS1' L=1.8e-7
MN_FA13_X1_00B FA13_X1_n00 FA13_X1_bb 0 0 NM W='1.7999999999999999e-06*WS1' L=1.8e-7
MN_FA13_X1_11A sum13 p13 FA13_X1_n11 0 NM W='1.7999999999999999e-06*WS1' L=1.8e-7
MN_FA13_X1_11B FA13_X1_n11 c13 0 0 NM W='1.7999999999999999e-06*WS1' L=1.8e-7
MP_FA13_X1_01A sum13 p13 FA13_X1_p01 vdd PM W='3.5999999999999998e-06*WS1' L=1.8e-7
MP_FA13_X1_01B FA13_X1_p01 FA13_X1_bb vdd vdd PM W='3.5999999999999998e-06*WS1' L=1.8e-7
MP_FA13_X1_10A sum13 FA13_X1_ab FA13_X1_p10 vdd PM W='3.5999999999999998e-06*WS1' L=1.8e-7
MP_FA13_X1_10B FA13_X1_p10 c13 vdd vdd PM W='3.5999999999999998e-06*WS1' L=1.8e-7
MN_FA13_NAB_A nab13 a13 FA13_NAB_mid 0 NM W='2.3999999999999999e-06*WS2' L=1.8e-7
MN_FA13_NAB_B FA13_NAB_mid b13 0 0 NM W='2.3999999999999999e-06*WS2' L=1.8e-7
MP_FA13_NAB_A nab13 a13 vdd vdd PM W='4.7999999999999998e-06*WS2' L=1.8e-7
MP_FA13_NAB_B nab13 b13 vdd vdd PM W='4.7999999999999998e-06*WS2' L=1.8e-7
MN_FA13_NPC_A npc13 p13 FA13_NPC_mid 0 NM W='2.3999999999999999e-06*WS2' L=1.8e-7
MN_FA13_NPC_B FA13_NPC_mid c13 0 0 NM W='2.3999999999999999e-06*WS2' L=1.8e-7
MP_FA13_NPC_A npc13 p13 vdd vdd PM W='4.7999999999999998e-06*WS2' L=1.8e-7
MP_FA13_NPC_B npc13 c13 vdd vdd PM W='4.7999999999999998e-06*WS2' L=1.8e-7
MN_FA13_COUT_A c14 nab13 FA13_COUT_mid 0 NM W='7.9999999999999996e-06*WS3' L=1.8e-7
MN_FA13_COUT_B FA13_COUT_mid npc13 0 0 NM W='7.9999999999999996e-06*WS3' L=1.8e-7
MP_FA13_COUT_A c14 nab13 vdd vdd PM W='1.5999999999999999e-05*WS3' L=1.8e-7
MP_FA13_COUT_B c14 npc13 vdd vdd PM W='1.5999999999999999e-05*WS3' L=1.8e-7
MN_FA14_X0_IA FA14_X0_ab a14 0 0 NM W='1.1999999999999999e-06*WS0' L=1.8e-7
MP_FA14_X0_IA FA14_X0_ab a14 vdd vdd PM W='2.3999999999999999e-06*WS0' L=1.8e-7
MN_FA14_X0_IB FA14_X0_bb b14 0 0 NM W='1.1999999999999999e-06*WS0' L=1.8e-7
MP_FA14_X0_IB FA14_X0_bb b14 vdd vdd PM W='2.3999999999999999e-06*WS0' L=1.8e-7
MN_FA14_X0_00A p14 FA14_X0_ab FA14_X0_n00 0 NM W='1.7999999999999999e-06*WS1' L=1.8e-7
MN_FA14_X0_00B FA14_X0_n00 FA14_X0_bb 0 0 NM W='1.7999999999999999e-06*WS1' L=1.8e-7
MN_FA14_X0_11A p14 a14 FA14_X0_n11 0 NM W='1.7999999999999999e-06*WS1' L=1.8e-7
MN_FA14_X0_11B FA14_X0_n11 b14 0 0 NM W='1.7999999999999999e-06*WS1' L=1.8e-7
MP_FA14_X0_01A p14 a14 FA14_X0_p01 vdd PM W='3.5999999999999998e-06*WS1' L=1.8e-7
MP_FA14_X0_01B FA14_X0_p01 FA14_X0_bb vdd vdd PM W='3.5999999999999998e-06*WS1' L=1.8e-7
MP_FA14_X0_10A p14 FA14_X0_ab FA14_X0_p10 vdd PM W='3.5999999999999998e-06*WS1' L=1.8e-7
MP_FA14_X0_10B FA14_X0_p10 b14 vdd vdd PM W='3.5999999999999998e-06*WS1' L=1.8e-7
MN_FA14_X1_IA FA14_X1_ab p14 0 0 NM W='1.1999999999999999e-06*WS0' L=1.8e-7
MP_FA14_X1_IA FA14_X1_ab p14 vdd vdd PM W='2.3999999999999999e-06*WS0' L=1.8e-7
MN_FA14_X1_IB FA14_X1_bb c14 0 0 NM W='1.1999999999999999e-06*WS0' L=1.8e-7
MP_FA14_X1_IB FA14_X1_bb c14 vdd vdd PM W='2.3999999999999999e-06*WS0' L=1.8e-7
MN_FA14_X1_00A sum14 FA14_X1_ab FA14_X1_n00 0 NM W='1.7999999999999999e-06*WS1' L=1.8e-7
MN_FA14_X1_00B FA14_X1_n00 FA14_X1_bb 0 0 NM W='1.7999999999999999e-06*WS1' L=1.8e-7
MN_FA14_X1_11A sum14 p14 FA14_X1_n11 0 NM W='1.7999999999999999e-06*WS1' L=1.8e-7
MN_FA14_X1_11B FA14_X1_n11 c14 0 0 NM W='1.7999999999999999e-06*WS1' L=1.8e-7
MP_FA14_X1_01A sum14 p14 FA14_X1_p01 vdd PM W='3.5999999999999998e-06*WS1' L=1.8e-7
MP_FA14_X1_01B FA14_X1_p01 FA14_X1_bb vdd vdd PM W='3.5999999999999998e-06*WS1' L=1.8e-7
MP_FA14_X1_10A sum14 FA14_X1_ab FA14_X1_p10 vdd PM W='3.5999999999999998e-06*WS1' L=1.8e-7
MP_FA14_X1_10B FA14_X1_p10 c14 vdd vdd PM W='3.5999999999999998e-06*WS1' L=1.8e-7
MN_FA14_NAB_A nab14 a14 FA14_NAB_mid 0 NM W='2.3999999999999999e-06*WS2' L=1.8e-7
MN_FA14_NAB_B FA14_NAB_mid b14 0 0 NM W='2.3999999999999999e-06*WS2' L=1.8e-7
MP_FA14_NAB_A nab14 a14 vdd vdd PM W='4.7999999999999998e-06*WS2' L=1.8e-7
MP_FA14_NAB_B nab14 b14 vdd vdd PM W='4.7999999999999998e-06*WS2' L=1.8e-7
MN_FA14_NPC_A npc14 p14 FA14_NPC_mid 0 NM W='2.3999999999999999e-06*WS2' L=1.8e-7
MN_FA14_NPC_B FA14_NPC_mid c14 0 0 NM W='2.3999999999999999e-06*WS2' L=1.8e-7
MP_FA14_NPC_A npc14 p14 vdd vdd PM W='4.7999999999999998e-06*WS2' L=1.8e-7
MP_FA14_NPC_B npc14 c14 vdd vdd PM W='4.7999999999999998e-06*WS2' L=1.8e-7
MN_FA14_COUT_A c15 nab14 FA14_COUT_mid 0 NM W='7.9999999999999996e-06*WS3' L=1.8e-7
MN_FA14_COUT_B FA14_COUT_mid npc14 0 0 NM W='7.9999999999999996e-06*WS3' L=1.8e-7
MP_FA14_COUT_A c15 nab14 vdd vdd PM W='1.5999999999999999e-05*WS3' L=1.8e-7
MP_FA14_COUT_B c15 npc14 vdd vdd PM W='1.5999999999999999e-05*WS3' L=1.8e-7
MN_FA15_X0_IA FA15_X0_ab a15 0 0 NM W='1.1999999999999999e-06*WS0' L=1.8e-7
MP_FA15_X0_IA FA15_X0_ab a15 vdd vdd PM W='2.3999999999999999e-06*WS0' L=1.8e-7
MN_FA15_X0_IB FA15_X0_bb b15 0 0 NM W='1.1999999999999999e-06*WS0' L=1.8e-7
MP_FA15_X0_IB FA15_X0_bb b15 vdd vdd PM W='2.3999999999999999e-06*WS0' L=1.8e-7
MN_FA15_X0_00A p15 FA15_X0_ab FA15_X0_n00 0 NM W='1.7999999999999999e-06*WS1' L=1.8e-7
MN_FA15_X0_00B FA15_X0_n00 FA15_X0_bb 0 0 NM W='1.7999999999999999e-06*WS1' L=1.8e-7
MN_FA15_X0_11A p15 a15 FA15_X0_n11 0 NM W='1.7999999999999999e-06*WS1' L=1.8e-7
MN_FA15_X0_11B FA15_X0_n11 b15 0 0 NM W='1.7999999999999999e-06*WS1' L=1.8e-7
MP_FA15_X0_01A p15 a15 FA15_X0_p01 vdd PM W='3.5999999999999998e-06*WS1' L=1.8e-7
MP_FA15_X0_01B FA15_X0_p01 FA15_X0_bb vdd vdd PM W='3.5999999999999998e-06*WS1' L=1.8e-7
MP_FA15_X0_10A p15 FA15_X0_ab FA15_X0_p10 vdd PM W='3.5999999999999998e-06*WS1' L=1.8e-7
MP_FA15_X0_10B FA15_X0_p10 b15 vdd vdd PM W='3.5999999999999998e-06*WS1' L=1.8e-7
MN_FA15_X1_IA FA15_X1_ab p15 0 0 NM W='1.1999999999999999e-06*WS0' L=1.8e-7
MP_FA15_X1_IA FA15_X1_ab p15 vdd vdd PM W='2.3999999999999999e-06*WS0' L=1.8e-7
MN_FA15_X1_IB FA15_X1_bb c15 0 0 NM W='1.1999999999999999e-06*WS0' L=1.8e-7
MP_FA15_X1_IB FA15_X1_bb c15 vdd vdd PM W='2.3999999999999999e-06*WS0' L=1.8e-7
MN_FA15_X1_00A sum15 FA15_X1_ab FA15_X1_n00 0 NM W='1.7999999999999999e-06*WS1' L=1.8e-7
MN_FA15_X1_00B FA15_X1_n00 FA15_X1_bb 0 0 NM W='1.7999999999999999e-06*WS1' L=1.8e-7
MN_FA15_X1_11A sum15 p15 FA15_X1_n11 0 NM W='1.7999999999999999e-06*WS1' L=1.8e-7
MN_FA15_X1_11B FA15_X1_n11 c15 0 0 NM W='1.7999999999999999e-06*WS1' L=1.8e-7
MP_FA15_X1_01A sum15 p15 FA15_X1_p01 vdd PM W='3.5999999999999998e-06*WS1' L=1.8e-7
MP_FA15_X1_01B FA15_X1_p01 FA15_X1_bb vdd vdd PM W='3.5999999999999998e-06*WS1' L=1.8e-7
MP_FA15_X1_10A sum15 FA15_X1_ab FA15_X1_p10 vdd PM W='3.5999999999999998e-06*WS1' L=1.8e-7
MP_FA15_X1_10B FA15_X1_p10 c15 vdd vdd PM W='3.5999999999999998e-06*WS1' L=1.8e-7
MN_FA15_NAB_A nab15 a15 FA15_NAB_mid 0 NM W='2.3999999999999999e-06*WS2' L=1.8e-7
MN_FA15_NAB_B FA15_NAB_mid b15 0 0 NM W='2.3999999999999999e-06*WS2' L=1.8e-7
MP_FA15_NAB_A nab15 a15 vdd vdd PM W='4.7999999999999998e-06*WS2' L=1.8e-7
MP_FA15_NAB_B nab15 b15 vdd vdd PM W='4.7999999999999998e-06*WS2' L=1.8e-7
MN_FA15_NPC_A npc15 p15 FA15_NPC_mid 0 NM W='2.3999999999999999e-06*WS2' L=1.8e-7
MN_FA15_NPC_B FA15_NPC_mid c15 0 0 NM W='2.3999999999999999e-06*WS2' L=1.8e-7
MP_FA15_NPC_A npc15 p15 vdd vdd PM W='4.7999999999999998e-06*WS2' L=1.8e-7
MP_FA15_NPC_B npc15 c15 vdd vdd PM W='4.7999999999999998e-06*WS2' L=1.8e-7
MN_FA15_COUT_A c16 nab15 FA15_COUT_mid 0 NM W='7.9999999999999996e-06*WS3' L=1.8e-7
MN_FA15_COUT_B FA15_COUT_mid npc15 0 0 NM W='7.9999999999999996e-06*WS3' L=1.8e-7
MP_FA15_COUT_A c16 nab15 vdd vdd PM W='1.5999999999999999e-05*WS3' L=1.8e-7
MP_FA15_COUT_B c16 npc15 vdd vdd PM W='1.5999999999999999e-05*WS3' L=1.8e-7
MN_COUT_BUF0 cout_b c16 0 0 NM W='7.9999999999999996e-06*WS3' L=1.8e-7
MP_COUT_BUF0 cout_b c16 vdd vdd PM W='1.5999999999999999e-05*WS3' L=1.8e-7
MN_COUT_BUF1 cout cout_b 0 0 NM W='7.9999999999999996e-06*WS3' L=1.8e-7
MP_COUT_BUF1 cout cout_b vdd vdd PM W='1.5999999999999999e-05*WS3' L=1.8e-7
CLOAD_sum00 sum00 0 2e-14
CLOAD_sum05 sum05 0 2e-14
CLOAD_sum10 sum10 0 2e-14
CLOAD_sum15 sum15 0 2e-14
CLOAD_c04 c04 0 2e-14
CLOAD_c08 c08 0 2e-14
CLOAD_c12 c12 0 2e-14
CLOAD_cout cout 0 2e-14
.dc VDD 0.8 1.8 0.05
.print dc v(sum00) v(sum05) v(sum10) v(sum15) v(c04) v(c08) v(c12) v(cout) i(VDD)
.alter p000001
.param VTHN=0.4416960313164332 VTHP=-0.4532675514368949 U0N=0.054724914205196845 U0P=0.020404897023237323 RDSWN=97.576109085495176 RDSWP=116.85102835365008 VSATN=75478.12811154114 VSATP=77062.760408557355 ETA0N=0.080435244689600047 ETA0P=0.076607981130987865 WS0=1.0178994352543229 WS1=0.98263236961936784 WS2=1.0415687192824925 WS3=1.0547795127571304
.alter p000002
.param VTHN=0.46491769949940609 VTHP=-0.45865466766240509 U0N=0.046727852190048734 U0P=0.018425943840254033 RDSWN=104.78000927547589 RDSWP=113.35504216102532 VSATN=78677.730953723207 VSATP=74876.706575867516 ETA0N=0.080084308024550105 ETA0P=0.077970201016476295 WS0=1.088283844172778 WS1=0.9342640679167451 WS2=1.0713255540580897 WS3=0.99484078422620237
.alter p000003
.param VTHN=0.45667128430832954 VTHP=-0.47250069269426731 U0N=0.047759465422216825 U0P=0.01891063529661248 RDSWN=108.53063414393735 RDSWP=108.96779365498017 VSATN=86118.979285999318 VSATP=76162.810464638082 ETA0N=0.075014434473199387 ETA0P=0.078502203644315385 WS0=1.0371247722231445 WS1=1.0550425731897928 WS2=0.92532304738848803 WS3=1.0866314150251111
.alter p000004
.param VTHN=0.42887517271908149 VTHP=-0.44641858129778245 U0N=0.052076722159991443 U0P=0.018133164379206663 RDSWN=97.825918937038011 RDSWP=114.04744445207079 VSATN=81628.125581516491 VSATP=75439.647769938412 ETA0N=0.073789423157502532 ETA0P=0.087891071905445164 WS0=0.90157231341960808 WS1=0.90084149641583744 WS2=1.0885479940738818 WS3=1.0643917650893009
.alter p000005
.param VTHN=0.42062976228570609 VTHP=-0.47532511469164346 U0N=0.045986391342465655 U0P=0.0207865039080629 RDSWN=91.57719414651001 RDSWP=124.15476689493943 VSATN=73421.275473975227 VSATP=86011.616771304543 ETA0N=0.082291906621727029 ETA0P=0.075283092756474268 WS0=1.0738836304791741 WS1=1.0747705751756211 WS2=0.92023215427767324 WS3=1.0906466519882607
.alter p000006
.param VTHN=0.42138780776688017 VTHP=-0.42322228605583578 U0N=0.047359720325786003 U0P=0.02076627523936582 RDSWN=94.635862262155541 RDSWP=112.08739725960683 VSATN=85948.727223747919 VSATP=86077.072288854921 ETA0N=0.085976119657146022 ETA0P=0.086354164174372069 WS0=0.93949918453018033 WS1=1.0184266608053729 WS2=1.0827542532567387 WS3=0.92158507920998622
.alter p000007
.param VTHN=0.46812422049213187 VTHP=-0.43730854524382734 U0N=0.053452486719753722 U0P=0.01818899910651512 RDSWN=107.54347614911727 RDSWP=122.48052288265656 VSATN=75740.432771009859 VSATP=87484.796977788574 ETA0N=0.074216356099342698 ETA0P=0.081576772900871897 WS0=0.93697611759489019 WS1=0.99170689585539273 WS2=1.0460596227919086 WS3=1.0478662646431864
.alter p000008
.param VTHN=0.4736271953963182 VTHP=-0.42787136856370245 U0N=0.049086589780280382 U0P=0.01880149311864698 RDSWN=100.57080509450454 RDSWP=128.01324363712268 VSATN=87896.275986940629 VSATP=86794.766491619899 ETA0N=0.08277948353215947 ETA0P=0.074727202431229933 WS0=1.0558060639899538 WS1=0.93721643908579577 WS2=1.0958492461173266 WS3=0.93104808354788071
.alter p000009
.param VTHN=0.46113088651321543 VTHP=-0.45951877739644703 U0N=0.045507117306345879 U0P=0.020092225027548007 RDSWN=94.306886023369273 RDSWP=120.88687407697961 VSATN=76243.390353242459 VSATP=75871.08660228677 ETA0N=0.077750377671547605 ETA0P=0.081609608179626911 WS0=0.95857051896890766 WS1=0.90002993035741052 WS2=0.92645191792125892 WS3=1.0399229736609898
.alter p000010
.param VTHN=0.45404444337550692 VTHP=-0.44526248748522901 U0N=0.047378691626468468 U0P=0.018332848775408413 RDSWN=105.74139629776036 RDSWP=121.14472570783518 VSATN=79112.571770226961 VSATP=83688.404214029433 ETA0N=0.075485982983022268 ETA0P=0.077061072350568374 WS0=1.066898081309466 WS1=1.0980220808569094 WS2=1.0324536632477501 WS3=0.9884622483738883
.alter p000011
.param VTHN=0.47323242409370297 VTHP=-0.43391134824729866 U0N=0.053011773794342021 U0P=0.019130334161729566 RDSWN=105.83447483771815 RDSWP=116.28629336043042 VSATN=87760.933355770903 VSATP=72638.982889843814 ETA0N=0.081096953358928414 ETA0P=0.079421337906943515 WS0=0.98024539086601803 WS1=0.9505882583911015 WS2=0.92869247836939661 WS3=1.0253284893467645
.alter p000012
.param VTHN=0.4457378098221248 VTHP=-0.43591502358579559 U0N=0.046081427408600217 U0P=0.019018886208324128 RDSWN=100.75969591064674 RDSWP=128.96916030165517 VSATN=82272.583008271075 VSATP=84638.780188128192 ETA0N=0.085799870204509257 ETA0P=0.073691760059541089 WS0=1.0060757674169805 WS1=0.99009381928389717 WS2=0.96957565372771537 WS3=0.94463840119088727
.alter p000013
.param VTHN=0.45036997572507498 VTHP=-0.4340934330331116 U0N=0.053082025219420834 U0P=0.019657839028668422 RDSWN=102.06972799660751 RDSWP=109.35921718691797 VSATN=72763.615192496713 VSATP=85827.969343109493 ETA0N=0.085059623457668293 ETA0P=0.074821141390591234 WS0=0.9824837531255064 WS1=0.96624779296170427 WS2=1.0981016814617566 WS3=0.98283645456232938
.alter p000014
.param VTHN=0.42589150210194737 VTHP=-0.42981690055205241 U0N=0.048164641217214137 U0P=0.019412399622300285 RDSWN=99.436018622185287 RDSWP=123.64500754437195 VSATN=73588.834523961501 VSATP=74235.51483267505 ETA0N=0.086360138397820571 ETA0P=0.086477637980987454 WS0=1.0582909393322271 WS1=1.0796556259643169 WS2=0.97456747233434349 WS3=1.0291435933117381
.alter p000015
.param VTHN=0.42792153684236295 VTHP=-0.47714511023425005 U0N=0.05421779283834248 U0P=0.020563508130432343 RDSWN=98.043428282352693 RDSWP=113.19830233631106 VSATN=80985.015256673767 VSATP=79777.186760795579 ETA0N=0.078487142864782769 ETA0P=0.076857098800277052 WS0=0.96399362279344558 WS1=0.98157719369537166 WS2=1.0154306890387488 WS3=1.0216187323107231
.alter p000016
.param VTHN=0.47674935245046757 VTHP=-0.44581627164719484 U0N=0.046233018664728794 U0P=0.020195342769425861 RDSWN=109.31106631417734 RDSWP=109.00832995046163 VSATN=87776.501810399874 VSATP=86663.120256277107 ETA0N=0.079188562609036561 ETA0P=0.075250016709981771 WS0=1.0948795373682341 WS1=0.99300590520476761 WS2=1.055170189845112 WS3=0.92163185957686344
.alter p000017
.param VTHN=0.44287269005987751 VTHP=-0.4352500826314506 U0N=0.047225057657365913 U0P=0.019912416127296551 RDSWN=100.63185444199689 RDSWP=127.30887342008364 VSATN=83511.479932428163 VSATP=84911.693166896846 ETA0N=0.073439848765491811 ETA0P=0.086202000222877037 WS0=1.080573450728747 WS1=1.0541935177168966 WS2=1.086358713999735 WS3=0.92504829077261341
.alter p000018
.param VTHN=0.46604716207932573 VTHP=-0.47550367160792506 U0N=0.045185374062198601 U0P=0.021108287998445632 RDSWN=96.205353602716386 RDSWP=125.61571421186781 VSATN=87952.394238217239 VSATP=84254.51210770497 ETA0N=0.084544398602124038 ETA0P=0.085858793349139567 WS0=1.0964529786623103 WS1=1.032720695443232 WS2=1.0612142051958302 WS3=0.90314198747664542
.alter p000019
.param VTHN=0.47137355387929986 VTHP=-0.45640444557404863 U0N=0.045116013756376139 U0P=0.018075756325022993 RDSWN=90.183670874467026 RDSWP=129.68397319477307 VSATN=85893.354737531408 VSATP=72815.64950966055 ETA0N=0.087294283187993704 ETA0P=0.080982601471054752 WS0=1.0747660793456244 WS1=0.91878363108923977 WS2=1.0123204116125364 WS3=0.94050457079420668
.alter p000020
.param VTHN=0.43311604125471032 VTHP=-0.47315509651398119 U0N=0.054061359524004218 U0P=0.020083384712130663 RDSWN=106.08302853246711 RDSWP=114.21853675167812 VSATN=75219.776303912004 VSATP=76653.837331110335 ETA0N=0.072322389970367246 ETA0P=0.076230974102417068 WS0=1.0514721438728025 WS1=0.92719657647082343 WS2=1.085869201012754 WS3=0.96401929352660687
.alter p000021
.param VTHN=0.44021866282092953 VTHP=-0.47482897166145061 U0N=0.048292798380353018 U0P=0.020395006090049284 RDSWN=99.828885694364118 RDSWP=125.5678243174227 VSATN=81903.00999981942 VSATP=76278.891424847738 ETA0N=0.085710326198217293 ETA0P=0.073820357667436165 WS0=0.97002283308540305 WS1=0.9731366507195931 WS2=0.97214393910002261 WS3=0.9349773137206645
.alter p000022
.param VTHN=0.42152232425274616 VTHP=-0.47530837791992298 U0N=0.046448617222289774 U0P=0.020965040861766353 RDSWN=90.138097737193505 RDSWP=116.88919706658662 VSATN=74781.488135226886 VSATP=81041.320639165322 ETA0N=0.078379454496909862 ETA0P=0.078832430967311268 WS0=1.0590704049775483 WS1=1.0229222201027284 WS2=0.96308057283001058 WS3=1.0582823737011522
.alter p000023
.param VTHN=0.43615073866887327 VTHP=-0.42484588756280217 U0N=0.046807746755207637 U0P=0.018411680687166296 RDSWN=101.75102834374303 RDSWP=119.40069411214294 VSATN=84953.304986411138 VSATP=86271.005467163879 ETA0N=0.077721012603189643 ETA0P=0.075313543565217189 WS0=0.91555805101699095 WS1=0.90268618613158125 WS2=0.90377693121061842 WS3=1.0853196881546683
.alter p000024
.param VTHN=0.44811353170729173 VTHP=-0.45973419983862435 U0N=0.051222934873950368 U0P=0.021735422988188133 RDSWN=95.560481923687647 RDSWP=119.78772822279343 VSATN=72294.607105678035 VSATP=80888.471157468681 ETA0N=0.086036459082838898 ETA0P=0.084359178431292814 WS0=1.0810919897082478 WS1=1.058282046453378 WS2=1.0733395678090241 WS3=1.0960030475448317
.alter p000025
.param VTHN=0.46347000109739844 VTHP=-0.47167013958761739 U0N=0.049493375689986477 U0P=0.021479623573732856 RDSWN=96.395186292875891 RDSWP=124.94534427570062 VSATN=87590.251807589666 VSATP=79884.806273938666 ETA0N=0.085930980028019674 ETA0P=0.087907460721221867 WS0=0.93221648033921811 WS1=0.94352440909611923 WS2=1.0175544411869304 WS3=0.93312056439399493
.alter p000026
.param VTHN=0.42635239407932257 VTHP=-0.47989281563450942 U0N=0.047781291029107151 U0P=0.019247115849112127 RDSWN=90.510378040265394 RDSWP=115.1871628388667 VSATN=81279.557420326935 VSATP=72657.435695942782 ETA0N=0.087951333408454041 ETA0P=0.072297498279842762 WS0=1.0324966749193374 WS1=1.0674986238501356 WS2=0.97734788735536315 WS3=1.0374011557634957
.alter p000027
.param VTHN=0.44995152318846893 VTHP=-0.44670856146444371 U0N=0.051931172188713549 U0P=0.018416867717233245 RDSWN=104.2274247060127 RDSWP=129.89528921418753 VSATN=82548.108706397063 VSATP=83306.696522737941 ETA0N=0.083228667010698199 ETA0P=0.072023166687584836 WS0=0.91332643307738171 WS1=0.98913681852598612 WS2=1.0740678271606534 WS3=1.0473282034822495
.alter p000028
.param VTHN=0.4422583098660669 VTHP=-0.44421038991070694 U0N=0.05092425119371314 U0P=0.018343863216181731 RDSWN=104.5362162156559 RDSWP=110.84639744626251 VSATN=85187.037228827336 VSATP=80350.567437264646 ETA0N=0.077911555662780047 ETA0P=0.086539115326642671 WS0=0.92353367591394087 WS1=0.984333940213584 WS2=1.0130094396220228 WS3=1.0346900055980421
.alter p000029
.param VTHN=0.44555345860267698 VTHP=-0.44261648723499125 U0N=0.050559644696496195 U0P=0.018640458501275634 RDSWN=106.58006660200634 RDSWP=112.32380062661163 VSATN=74586.583640263038 VSATP=82128.673460117992 ETA0N=0.08667743240234338 ETA0P=0.074292402385943437 WS0=0.97323922865900203 WS1=1.0651045609752303 WS2=0.93876836828057864 WS3=1.0787970813581143
.alter p000030
.param VTHN=0.42680667809947664 VTHP=-0.44913844393550084 U0N=0.051869826518594786 U0P=0.021824661941313654 RDSWN=95.30079015219134 RDSWP=111.8509309257565 VSATN=75448.482501931489 VSATP=82195.847583136128 ETA0N=0.084195711686672989 ETA0P=0.080818362735527546 WS0=1.0816562513599099 WS1=1.0707627357752338 WS2=0.93645953459520237 WS3=0.98527471638167752
.alter p000031
.param VTHN=0.44758651059088733 VTHP=-0.45746761883613146 U0N=0.052597752318542752 U0P=0.01968939023636361 RDSWN=106.42398503475491 RDSWP=128.42776420494448 VSATN=83801.56157434333 VSATP=80863.193145113459 ETA0N=0.077643450485670784 ETA0P=0.084431566803319147 WS0=0.97268405770387478 WS1=0.97339317643257695 WS2=0.99147288541703593 WS3=0.940186764712167
.alter p000032
.param VTHN=0.43048552338114809 VTHP=-0.44917414658714955 U0N=0.049398810383216155 U0P=0.019681651852989 RDSWN=95.955872948152717 RDSWP=118.93335608846371 VSATN=81514.058281224148 VSATP=79243.276362645163 ETA0N=0.076135564590116056 ETA0P=0.074103198172691898 WS0=0.93753743902729358 WS1=0.90045936127411041 WS2=0.9042648717469185 WS3=0.95430923169218529
.alter p000033
.param VTHN=0.43547092054522285 VTHP=-0.4779551408880014 U0N=0.047885154379800655 U0P=0.020685695757301226 RDSWN=109.46266832613426 RDSWP=113.81377056020602 VSATN=73870.06881566385 VSATP=82521.31016410864 ETA0N=0.073826023309681216 ETA0P=0.072995499437995409 WS0=0.95947070630656339 WS1=1.0457600937107618 WS2=1.0026007577091345 WS3=1.032502377990089
.alter p000034
.param VTHN=0.4750069118989193 VTHP=-0.45446375218854573 U0N=0.053992213048173837 U0P=0.019478088205638473 RDSWN=107.64258071721981 RDSWP=130.53796108700152 VSATN=87424.721512912089 VSATP=81161.02439038147 ETA0N=0.083699182575617301 ETA0P=0.083172811016394579 WS0=1.0901091756691998 WS1=0.9094865627199481 WS2=0.949665096879304 WS3=1.0746162940705291
.alter p000035
.param VTHN=0.42002857946247868 VTHP=-0.4794789200993731 U0N=0.047720550572638194 U0P=0.020666920916797296 RDSWN=105.70654165126143 RDSWP=122.69506171305578 VSATN=84797.435157815547 VSATP=76804.609628656501 ETA0N=0.072681913443992566 ETA0P=0.076904680161051148 WS0=0.96637383766074592 WS1=1.0936261048364564 WS2=0.97963402345185935 WS3=1.0355523577848089
.alter p000036
.param VTHN=0.44941504008520444 VTHP=-0.44624441591507163 U0N=0.053684313112904614 U0P=0.019873354421621598 RDSWN=109.09200030598491 RDSWP=114.94906565121849 VSATN=87010.765804406357 VSATP=86977.928589783056 ETA0N=0.072406256073965017 ETA0P=0.082682429648919795 WS0=0.92243668953790825 WS1=0.98662150403053395 WS2=0.95467021186856349 WS3=0.90516027205108962
.alter p000037
.param VTHN=0.4287053473595443 VTHP=-0.45623222688532261 U0N=0.050782948822173407 U0P=0.018865391318337574 RDSWN=106.26867668728664 RDSWP=119.05687682870453 VSATN=77771.426841183042 VSATP=85657.001907128317 ETA0N=0.076296600482907873 ETA0P=0.087338531638395042 WS0=0.96451998508297054 WS1=1.0418039639230114 WS2=0.93405471114098249 WS3=0.99081727783982265
.alter p000038
.param VTHN=0.42458274308321353 VTHP=-0.47806377439067577 U0N=0.051969044693871973 U0P=0.019262255708281474 RDSWN=104.18988483679888 RDSWP=113.2889853306604 VSATN=75854.525088645882 VSATP=77452.056460172389 ETA0N=0.072904227261383944 ETA0P=0.080833532221615392 WS0=1.0100307982564265 WS1=1.0794540382318014 WS2=0.97191753715423601 WS3=0.90669682718237377
.alter p000039
.param VTHN=0.45717023761875675 VTHP=-0.42944388733541572 U0N=0.050941033190008964 U0P=0.021024022536584478 RDSWN=97.84216610760528 RDSWP=109.92650186672385 VSATN=83909.961067306358 VSATP=84697.572208260506 ETA0N=0.087700623715637943 ETA0P=0.085288018444640401 WS0=1.0412226683457102 WS1=1.0393012297346951 WS2=1.0249780124903607 WS3=0.91745826771112737
.alter p000040
.param VTHN=0.46778139479323116 VTHP=-0.43598382154775595 U0N=0.053140011941643341 U0P=0.018548038888764756 RDSWN=109.37466476243233 RDSWP=118.07077845905815 VSATN=84324.624879808471 VSATP=81495.178213255218 ETA0N=0.078906689591196802 ETA0P=0.072877226973487558 WS0=1.0793979829922353 WS1=0.9399813134488183 WS2=1.0731697143228258 WS3=0.91956741754512905
.alter p000041
.param VTHN=0.47100534002471717 VTHP=-0.46200227947617656 U0N=0.045158988858499095 U0P=0.020030983874784438 RDSWN=101.81989911574331 RDSWP=129.57539528703131 VSATN=79609.333317704324 VSATP=73391.502997183954 ETA0N=0.077419018761324759 ETA0P=0.087324900990737947 WS0=1.0410708099910131 WS1=1.0245041584057519 WS2=1.0789593296323989 WS3=0.91661862032866914
.alter p000042
.param VTHN=0.42561960453719627 VTHP=-0.45064991379263297 U0N=0.050201049879777387 U0P=0.01810205584092929 RDSWN=97.600977846740051 RDSWP=110.75021786510801 VSATN=81678.734762206252 VSATP=75393.866319815672 ETA0N=0.078161520720021332 ETA0P=0.072415097204934692 WS0=1.0221607141475535 WS1=1.00001683979112 WS2=0.90728371569014388 WS3=0.9797329312456019
.alter p000043
.param VTHN=0.44532747810209117 VTHP=-0.42759172877968071 U0N=0.048031772286232226 U0P=0.021366349436951385 RDSWN=105.04569267953801 RDSWP=113.78949375346234 VSATN=76446.794228214625 VSATP=72875.858231383565 ETA0N=0.077145944838808433 ETA0P=0.077129732554176697 WS0=1.0498357623538193 WS1=0.93248513981746228 WS2=1.0892795182562733 WS3=1.0834808574238894
.alter p000044
.param VTHN=0.43058979548298804 VTHP=-0.45604953686275951 U0N=0.049513290253177578 U0P=0.019086037056737774 RDSWN=102.196818793909 RDSWP=114.30593553731023 VSATN=79430.234545168321 VSATP=81123.007784516129 ETA0N=0.074949993262998241 ETA0P=0.072850046001397412 WS0=0.92753009167949496 WS1=0.93790839516877411 WS2=1.0944061887196246 WS3=1.067865861867864
.alter p000045
.param VTHN=0.45347449468731343 VTHP=-0.44405365209971914 U0N=0.046325897469542639 U0P=0.020511657400195914 RDSWN=97.385957303320083 RDSWP=123.03546335859474 VSATN=73998.761404523 VSATP=83341.732770111965 ETA0N=0.073505186685461021 ETA0P=0.083030500875796956 WS0=1.0329253595250902 WS1=0.93682889901940902 WS2=1.0245484709204107 WS3=0.95584000995769391
.alter p000046
.param VTHN=0.4563734013712033 VTHP=-0.45836057254024848 U0N=0.049616656607798411 U0P=0.018586295227923644 RDSWN=106.38235400516439 RDSWP=108.72621259851023 VSATN=86820.963010539213 VSATP=81570.366272906453 ETA0N=0.087915790018983475 ETA0P=0.073524655099527936 WS0=0.93522403433596446 WS1=0.98573571500983825 WS2=0.94377548544454137 WS3=1.040180872670591
.alter p000047
.param VTHN=0.45560585135731285 VTHP=-0.45542288585423768 U0N=0.046405194005114253 U0P=0.020220628619400414 RDSWN=92.400738383780151 RDSWP=118.59436788796789 VSATN=84145.212761759627 VSATP=77820.421426597532 ETA0N=0.081996302339492608 ETA0P=0.078255431735585565 WS0=1.0643246055459181 WS1=0.94732895200260658 WS2=1.0752863583373411 WS3=0.95931442576254111
.alter p000048
.param VTHN=0.4517027298299045 VTHP=-0.42468934034669981 U0N=0.04613100620876056 U0P=0.01926702226937799 RDSWN=94.326812634922916 RDSWP=109.68279094963547 VSATN=78009.586160662555 VSATP=83487.857708905183 ETA0N=0.086369320485201198 ETA0P=0.075705644640004968 WS0=1.0997282464855502 WS1=0.93559586814103068 WS2=0.97811729241485978 WS3=1.077939244451217
.alter p000049
.param VTHN=0.42999917579907726 VTHP=-0.46871542292817364 U0N=0.046035428527725381 U0P=0.019543602024094827 RDSWN=93.761999762338931 RDSWP=113.86304929849372 VSATN=75985.889055620966 VSATP=82422.711456301928 ETA0N=0.083979556093815438 ETA0P=0.079057848078298243 WS0=1.0447677001657778 WS1=0.95695384795244898 WS2=0.90231261620065517 WS3=1.0928830344806484
.end
