* fair-comparison p000000 dc
.option nomod method=gear reltol=1e-6 vntol=1e-9 abstol=1e-13 gmin=1e-12 itl1=200
.param VTHN=0.45126483051096039 VTHP=-0.43712328775058912 U0N=0.054472227924512562 U0P=0.019642227633496968 RDSWN=95.093588416662513 RDSWP=125.06632680402315 VSATN=87504.447322012653 VSATP=75147.443178696412 ETA0N=0.086119024107108172 ETA0P=0.072375500135660659 WS0=0.9297506302192986 WS1=1.0376459501931772 WS2=0.95303198059391914 WS3=1.02285909173834
.temp 25
.model NM NMOS (LEVEL=54 VERSION=4.7.0 TNOM=25 TOXE=1.5e-09 DTOX=0 EPSROX=3.8999999999999999 XJ=9.9999999999999995e-08 NSD=1e+20 NGATE=0 PHIN=0 K1=0.53000000000000003 K2=-0.018599999999999998 K3=0 K3B=0 W0=2.5000000000000002e-06 DVT0=2.2000000000000002 DVT1=0.53000000000000003 DVT2=-0.032000000000000001 DVT0W=0 DVT1W=5300000 DVT2W=-0.032000000000000001 UA=1.0000000000000001e-09 UB=1.0000000000000001e-18 UC=-4.6500000000000001e-11 A0=1 AGS=0 B0=0 B1=0 KETA=-0.047 A1=0 A2=1 PRWG=0 PRWB=0 WR=1 DWG=0 DWB=0 VOFF=-0.080000000000000002 NFACTOR=1 ETAB=-0.070000000000000007 PCLM=1.3 PDIBLC1=0.39000000000000001 PDIBLC2=0.0086 PDIBLCB=0 DROUT=0.56000000000000005 PVAG=0 DELTA=0.01 MOBMOD=0 CAPMOD=2 RDSMOD=0 RGATEMOD=0 NDEP=1.7e+17 VTH0='VTHN' U0='U0N' RDSW='RDSWN' VSAT='VSATN' ETA0='ETA0N')
.model PM PMOS (LEVEL=54 VERSION=4.7.0 TNOM=25 TOXE=1.5e-09 DTOX=0 EPSROX=3.8999999999999999 XJ=9.9999999999999995e-08 NSD=1e+20 NGATE=0 PHIN=0 K1=0.53000000000000003 K2=-0.018599999999999998 K3=0 K3B=0 W0=2.5000000000000002e-06 DVT0=2.2000000000000002 DVT1=0.53000000000000003 DVT2=-0.032000000000000001 DVT0W=0 DVT1W=5300000 DVT2W=-0.032000000000000001 UA=1.0000000000000001e-09 UB=1.0000000000000001e-18 UC=-4.6500000000000001e-11 A0=1 AGS=0 B0=0 B1=0 KETA=-0.047 A1=0 A2=1 PRWG=0 PRWB=0 WR=1 DWG=0 DWB=0 VOFF=-0.080000000000000002 NFACTOR=1 ETAB=-0.070000000000000007 PCLM=1.3 PDIBLC1=0.39000000000000001 PDIBLC2=0.0086 PDIBLCB=0 DROUT=0.56000000000000005 PVAG=0 DELTA=0.01 MOBMOD=0 CAPMOD=2 RDSMOD=0 RGATEMOD=0 NDEP=1.2e+17 VTH0='VTHP' U0='U0P' RDSW='RDSWP' VSAT='VSATP' ETA0='ETA0P')
VDD vdd 0 1.8
EA00 a00 0 vdd 0 1
VA01 a01 0 0
EA02 a02 0 vdd 0 1
VA03 a03 0 0
VA04 a04 0 0
EA05 a05 0 vdd 0 1
VA06 a06 0 0
EA07 a07 0 vdd 0 1
EA08 a08 0 vdd 0 1
VA09 a09 0 0
EA10 a10 0 vdd 0 1
VA11 a11 0 0
VA12 a12 0 0
EA13 a13 0 vdd 0 1
VA14 a14 0 0
EA15 a15 0 vdd 0 1
VB00 b00 0 0
VB01 b01 0 0
EB02 b02 0 vdd 0 1
EB03 b03 0 vdd 0 1
EB04 b04 0 vdd 0 1
EB05 b05 0 vdd 0 1
VB06 b06 0 0
VB07 b07 0 0
VB08 b08 0 0
EB09 b09 0 vdd 0 1
VB10 b10 0 0
EB11 b11 0 vdd 0 1
EB12 b12 0 vdd 0 1
VB13 b13 0 0
EB14 b14 0 vdd 0 1
VB15 b15 0 0
ECIN cin 0 vdd 0 1
MN_FA00_X0_IA FA00_X0_ab a00 0 0 NM W='1.1999999999999999e-06*WS0' L=1.8e-7
MP_FA00_X0_IA FA00_X0_ab a00 vdd vdd PM W='2.3999999999999999e-06*WS0' L=1.8e-7
MN_FA00_X0_IB FA00_X0_bb b00 0 0 NM W='1.1999999999999999e-06*WS0' L=1.8e-7
MP_FA00_X0_IB FA00_X0_bb b00 vdd vdd PM W='2.3999999999999999e-06*WS0' L=1.8e-7
MN_FA00_X0_00A p00 FA00_X0_ab FA00_X0_n00 0 NM W='1.7999999999999999e-06*WS1' L=1.8e-7
MN_FA00_X0_00B FA00_X0_n00 FA00_X0_bb 0 0 NM W='1.7999999999999999e-06*WS1' L=1.8e-7
MN_FA00_X0_11A p00 a00 FA00_X0_n11 0 NM W='1.7999999999999999e-06*WS1' L=1.8e-7
MN_FA00_X0_11B FA00_X0_n11 b00 0 0 NM W='1.7999999999999999e-06*WS1' L=1.8e-7
MP_FA00_X0_01A p00 a00 FA00_X0_p01 vdd PM W='3.5999999999999998e-06*WS1' L=1.8e-7
MP_FA00_X0_01B FA00_X0_p01 FA00_X0_bb vdd vdd PM W='3.5999999999999998e-06*WS1' L=1.8e-7
MP_FA00_X0_10A p00 FA00_X0_ab FA00_X0_p10 vdd PM W='3.5999999999999998e-06*WS1' L=1.8e-7
MP_FA00_X0_10B FA00_X0_p10 b00 vdd vdd PM W='3.5999999999999998e-06*WS1' L=1.8e-7
MN_FA00_X1_IA FA00_X1_ab p00 0 0 NM W='1.1999999999999999e-06*WS0' L=1.8e-7
MP_FA00_X1_IA FA00_X1_ab p00 vdd vdd PM W='2.3999999999999999e-06*WS0' L=1.8e-7
MN_FA00_X1_IB FA00_X1_bb cin 0 0 NM W='1.1999999999999999e-06*WS0' L=1.8e-7
MP_FA00_X1_IB FA00_X1_bb cin vdd vdd PM W='2.3999999999999999e-06*WS0' L=1.8e-7
MN_FA00_X1_00A sum00 FA00_X1_ab FA00_X1_n00 0 NM W='1.7999999999999999e-06*WS1' L=1.8e-7
MN_FA00_X1_00B FA00_X1_n00 FA00_X1_bb 0 0 NM W='1.7999999999999999e-06*WS1' L=1.8e-7
MN_FA00_X1_11A sum00 p00 FA00_X1_n11 0 NM W='1.7999999999999999e-06*WS1' L=1.8e-7
MN_FA00_X1_11B FA00_X1_n11 cin 0 0 NM W='1.7999999999999999e-06*WS1' L=1.8e-7
MP_FA00_X1_01A sum00 p00 FA00_X1_p01 vdd PM W='3.5999999999999998e-06*WS1' L=1.8e-7
MP_FA00_X1_01B FA00_X1_p01 FA00_X1_bb vdd vdd PM W='3.5999999999999998e-06*WS1' L=1.8e-7
MP_FA00_X1_10A sum00 FA00_X1_ab FA00_X1_p10 vdd PM W='3.5999999999999998e-06*WS1' L=1.8e-7
MP_FA00_X1_10B FA00_X1_p10 cin vdd vdd PM W='3.5999999999999998e-06*WS1' L=1.8e-7
MN_FA00_NAB_A nab00 a00 FA00_NAB_mid 0 NM W='2.3999999999999999e-06*WS2' L=1.8e-7
MN_FA00_NAB_B FA00_NAB_mid b00 0 0 NM W='2.3999999999999999e-06*WS2' L=1.8e-7
MP_FA00_NAB_A nab00 a00 vdd vdd PM W='4.7999999999999998e-06*WS2' L=1.8e-7
MP_FA00_NAB_B nab00 b00 vdd vdd PM W='4.7999999999999998e-06*WS2' L=1.8e-7
MN_FA00_NPC_A npc00 p00 FA00_NPC_mid 0 NM W='2.3999999999999999e-06*WS2' L=1.8e-7
MN_FA00_NPC_B FA00_NPC_mid cin 0 0 NM W='2.3999999999999999e-06*WS2' L=1.8e-7
MP_FA00_NPC_A npc00 p00 vdd vdd PM W='4.7999999999999998e-06*WS2' L=1.8e-7
MP_FA00_NPC_B npc00 cin vdd vdd PM W='4.7999999999999998e-06*WS2' L=1.8e-7
MN_FA00_COUT_A c01 nab00 FA00_COUT_mid 0 NM W='7.9999999999999996e-06*WS3' L=1.8e-7
MN_FA00_COUT_B FA00_COUT_mid npc00 0 0 NM W='7.9999999999999996e-06*WS3' L=1.8e-7
MP_FA00_COUT_A c01 nab00 vdd vdd PM W='1.5999999999999999e-05*WS3' L=1.8e-7
MP_FA00_COUT_B c01 npc00 vdd vdd PM W='1.5999999999999999e-05*WS3' L=1.8e-7
MN_FA01_X0_IA FA01_X0_ab a01 0 0 NM W='1.1999999999999999e-06*WS0' L=1.8e-7
MP_FA01_X0_IA FA01_X0_ab a01 vdd vdd PM W='2.3999999999999999e-06*WS0' L=1.8e-7
MN_FA01_X0_IB FA01_X0_bb b01 0 0 NM W='1.1999999999999999e-06*WS0' L=1.8e-7
MP_FA01_X0_IB FA01_X0_bb b01 vdd vdd PM W='2.3999999999999999e-06*WS0' L=1.8e-7
MN_FA01_X0_00A p01 FA01_X0_ab FA01_X0_n00 0 NM W='1.7999999999999999e-06*WS1' L=1.8e-7
MN_FA01_X0_00B FA01_X0_n00 FA01_X0_bb 0 0 NM W='1.7999999999999999e-06*WS1' L=1.8e-7
MN_FA01_X0_11A p01 a01 FA01_X0_n11 0 NM W='1.7999999999999999e-06*WS1' L=1.8e-7
MN_FA01_X0_11B FA01_X0_n11 b01 0 0 NM W='1.7999999999999999e-06*WS1' L=1.8e-7
MP_FA01_X0_01A p01 a01 FA01_X0_p01 vdd PM W='3.5999999999999998e-06*WS1' L=1.8e-7
MP_FA01_X0_01B FA01_X0_p01 FA01_X0_bb vdd vdd PM W='3.5999999999999998e-06*WS1' L=1.8e-7
MP_FA01_X0_10A p01 FA01_X0_ab FA01_X0_p10 vdd PM W='3.5999999999999998e-06*WS1' L=1.8e-7
MP_FA01_X0_10B FA01_X0_p10 b01 vdd vdd PM W='3.5999999999999998e-06*WS1' L=1.8e-7
MN_FA01_X1_IA FA01_X1_ab p01 0 0 NM W='1.1999999999999999e-06*WS0' L=1.8e-7
MP_FA01_X1_IA FA01_X1_ab p01 vdd vdd PM W='2.3999999999999999e-06*WS0' L=1.8e-7
MN_FA01_X1_IB FA01_X1_bb c01 0 0 NM W='1.1999999999999999e-06*WS0' L=1.8e-7
MP_FA01_X1_IB FA01_X1_bb c01 vdd vdd PM W='2.3999999999999999e-06*WS0' L=1.8e-7
MN_FA01_X1_00A sum01 FA01_X1_ab FA01_X1_n00 0 NM W='1.7999999999999999e-06*WS1' L=1.8e-7
MN_FA01_X1_00B FA01_X1_n00 FA01_X1_bb 0 0 NM W='1.7999999999999999e-06*WS1' L=1.8e-7
MN_FA01_X1_11A sum01 p01 FA01_X1_n11 0 NM W='1.7999999999999999e-06*WS1' L=1.8e-7
MN_FA01_X1_11B FA01_X1_n11 c01 0 0 NM W='1.7999999999999999e-06*WS1' L=1.8e-7
MP_FA01_X1_01A sum01 p01 FA01_X1_p01 vdd PM W='3.5999999999999998e-06*WS1' L=1.8e-7
MP_FA01_X1_01B FA01_X1_p01 FA01_X1_bb vdd vdd PM W='3.5999999999999998e-06*WS1' L=1.8e-7
MP_FA01_X1_10A sum01 FA01_X1_ab FA01_X1_p10 vdd PM W='3.5999999999999998e-06*WS1' L=1.8e-7
MP_FA01_X1_10B FA01_X1_p10 c01 vdd vdd PM W='3.5999999999999998e-06*WS1' L=1.8e-7
MN_FA01_NAB_A nab01 a01 FA01_NAB_mid 0 NM W='2.3999999999999999e-06*WS2' L=1.8e-7
MN_FA01_NAB_B FA01_NAB_mid b01 0 0 NM W='2.3999999999999999e-06*WS2' L=1.8e-7
MP_FA01_NAB_A nab01 a01 vdd vdd PM W='4.7999999999999998e-06*WS2' L=1.8e-7
MP_FA01_NAB_B nab01 b01 vdd vdd PM W='4.7999999999999998e-06*WS2' L=1.8e-7
MN_FA01_NPC_A npc01 p01 FA01_NPC_mid 0 NM W='2.3999999999999999e-06*WS2' L=1.8e-7
MN_FA01_NPC_B FA01_NPC_mid c01 0 0 NM W='2.3999999999999999e-06*WS2' L=1.8e-7
MP_FA01_NPC_A npc01 p01 vdd vdd PM W='4.7999999999999998e-06*WS2' L=1.8e-7
MP_FA01_NPC_B npc01 c01 vdd vdd PM W='4.7999999999999998e-06*WS2' L=1.8e-7
MN_FA01_COUT_A c02 nab01 FA01_COUT_mid 0 NM W='7.9999999999999996e-06*WS3' L=1.8e-7
MN_FA01_COUT_B FA01_COUT_mid npc01 0 0 NM W='7.9999999999999996e-06*WS3' L=1.8e-7
MP_FA01_COUT_A c02 nab01 vdd vdd PM W='1.5999999999999999e-05*WS3' L=1.8e-7
MP_FA01_COUT_B c02 npc01 vdd vdd PM W='1.5999999999999999e-05*WS3' L=1.8e-7
MN_FA02_X0_IA FA02_X0_ab a02 0 0 NM W='1.1999999999999999e-06*WS0' L=1.8e-7
MP_FA02_X0_IA FA02_X0_ab a02 vdd vdd PM W='2.3999999999999999e-06*WS0' L=1.8e-7
MN_FA02_X0_IB FA02_X0_bb b02 0 0 NM W='1.1999999999999999e-06*WS0' L=1.8e-7
MP_FA02_X0_IB FA02_X0_bb b02 vdd vdd PM W='2.3999999999999999e-06*WS0' L=1.8e-7
MN_FA02_X0_00A p02 FA02_X0_ab FA02_X0_n00 0 NM W='1.7999999999999999e-06*WS1' L=1.8e-7
MN_FA02_X0_00B FA02_X0_n00 FA02_X0_bb 0 0 NM W='1.7999999999999999e-06*WS1' L=1.8e-7
MN_FA02_X0_11A p02 a02 FA02_X0_n11 0 NM W='1.7999999999999999e-06*WS1' L=1.8e-7
MN_FA02_X0_11B FA02_X0_n11 b02 0 0 NM W='1.7999999999999999e-06*WS1' L=1.8e-7
MP_FA02_X0_01A p02 a02 FA02_X0_p01 vdd PM W='3.5999999999999998e-06*WS1' L=1.8e-7
MP_FA02_X0_01B FA02_X0_p01 FA02_X0_bb vdd vdd PM W='3.5999999999999998e-06*WS1' L=1.8e-7
MP_FA02_X0_10A p02 FA02_X0_ab FA02_X0_p10 vdd PM W='3.5999999999999998e-06*WS1' L=1.8e-7
MP_FA02_X0_10B FA02_X0_p10 b02 vdd vdd PM W='3.5999999999999998e-06*WS1' L=1.8e-7
MN_FA02_X1_IA FA02_X1_ab p02 0 0 NM W='1.1999999999999999e-06*WS0' L=1.8e-7
MP_FA02_X1_IA FA02_X1_ab p02 vdd vdd PM W='2.3999999999999999e-06*WS0' L=1.8e-7
MN_FA02_X1_IB FA02_X1_bb c02 0 0 NM W='1.1999999999999999e-06*WS0' L=1.8e-7
MP_FA02_X1_IB FA02_X1_bb c02 vdd vdd PM W='2.3999999999999999e-06*WS0' L=1.8e-7
MN_FA02_X1_00A sum02 FA02_X1_ab FA02_X1_n00 0 NM W='1.7999999999999999e-06*WS1' L=1.8e-7
MN_FA02_X1_00B FA02_X1_n00 FA02_X1_bb 0 0 NM W='1.7999999999999999e-06*WS1' L=1.8e-7
MN_FA02_X1_11A sum02 p02 FA02_X1_n11 0 NM W='1.7999999999999999e-06*WS1' L=1.8e-7
MN_FA02_X1_11B FA02_X1_n11 c02 0 0 NM W='1.7999999999999999e-06*WS1' L=1.8e-7
MP_FA02_X1_01A sum02 p02 FA02_X1_p01 vdd PM W='3.5999999999999998e-06*WS1' L=1.8e-7
MP_FA02_X1_01B FA02_X1_p01 FA02_X1_bb vdd vdd PM W='3.5999999999999998e-06*WS1' L=1.8e-7
MP_FA02_X1_10A sum02 FA02_X1_ab FA02_X1_p10 vdd PM W='3.5999999999999998e-06*WS1' L=1.8e-7
MP_FA02_X1_10B FA02_X1_p10 c02 vdd vdd PM W='3.5999999999999998e-06*WS1' L=1.8e-7
MN_FA02_NAB_A nab02 a02 FA02_NAB_mid 0 NM W='2.3999999999999999e-06*WS2' L=1.8e-7
MN_FA02_NAB_B FA02_NAB_mid b02 0 0 NM W='2.3999999999999999e-06*WS2' L=1.8e-7
MP_FA02_NAB_A nab02 a02 vdd vdd PM W='4.7999999999999998e-06*WS2' L=1.8e-7
MP_FA02_NAB_B nab02 b02 vdd vdd PM W='4.7999999999999998e-06*WS2' L=1.8e-7
MN_FA02_NPC_A npc02 p02 FA02_NPC_mid 0 NM W='2.3999999999999999e-06*WS2' L=1.8e-7
MN_FA02_NPC_B FA02_NPC_mid c02 0 0 NM W='2.3999999999999999e-06*WS2' L=1.8e-7
MP_FA02_NPC_A npc02 p02 vdd vdd PM W='4.7999999999999998e-06*WS2' L=1.8e-7
MP_FA02_NPC_B npc02 c02 vdd vdd PM W='4.7999999999999998e-06*WS2' L=1.8e-7
MN_FA02_COUT_A c03 nab02 FA02_COUT_mid 0 NM W='7.9999999999999996e-06*WS3' L=1.8e-7
MN_FA02_COUT_B FA02_COUT_mid npc02 0 0 NM W='7.9999999999999996e-06*WS3' L=1.8e-7
MP_FA02_COUT_A c03 nab02 vdd vdd PM W='1.5999999999999999e-05*WS3' L=1.8e-7
MP_FA02_COUT_B c03 npc02 vdd vdd PM W='1.5999999999999999e-05*WS3' L=1.8e-7
MN_FA03_X0_IA FA03_X0_ab a03 0 0 NM W='1.1999999999999999e-06*WS0' L=1.8e-7
MP_FA03_X0_IA FA03_X0_ab a03 vdd vdd PM W='2.3999999999999999e-06*WS0' L=1.8e-7
MN_FA03_X0_IB FA03_X0_bb b03 0 0 NM W='1.1999999999999999e-06*WS0' L=1.8e-7
MP_FA03_X0_IB FA03_X0_bb b03 vdd vdd PM W='2.3999999999999999e-06*WS0' L=1.8e-7
MN_FA03_X0_00A p03 FA03_X0_ab FA03_X0_n00 0 NM W='1.7999999999999999e-06*WS1' L=1.8e-7
MN_FA03_X0_00B FA03_X0_n00 FA03_X0_bb 0 0 NM W='1.7999999999999999e-06*WS1' L=1.8e-7
MN_FA03_X0_11A p03 a03 FA03_X0_n11 0 NM W='1.7999999999999999e-06*WS1' L=1.8e-7
MN_FA03_X0_11B FA03_X0_n11 b03 0 0 NM W='1.7999999999999999e-06*WS1' L=1.8e-7
MP_FA03_X0_01A p03 a03 FA03_X0_p01 vdd PM W='3.5999999999999998e-06*WS1' L=1.8e-7
MP_FA03_X0_01B FA03_X0_p01 FA03_X0_bb vdd vdd PM W='3.5999999999999998e-06*WS1' L=1.8e-7
MP_FA03_X0_10A p03 FA03_X0_ab FA03_X0_p10 vdd PM W='3.5999999999999998e-06*WS1' L=1.8e-7
MP_FA03_X0_10B FA03_X0_p10 b03 vdd vdd PM W='3.5999999999999998e-06*WS1' L=1.8e-7
MN_FA03_X1_IA FA03_X1_ab p03 0 0 NM W='1.1999999999999999e-06*WS0' L=1.8e-7
MP_FA03_X1_IA FA03_X1_ab p03 vdd vdd PM W='2.3999999999999999e-06*WS0' L=1.8e-7
MN_FA03_X1_IB FA03_X1_bb c03 0 0 NM W='1.1999999999999999e-06*WS0' L=1.8e-7
MP_FA03_X1_IB FA03_X1_bb c03 vdd vdd PM W='2.3999999999999999e-06*WS0' L=1.8e-7
MN_FA03_X1_00A sum03 FA03_X1_ab FA03_X1_n00 0 NM W='1.7999999999999999e-06*WS1' L=1.8e-7
MN_FA03_X1_00B FA03_X1_n00 FA03_X1_bb 0 0 NM W='1.7999999999999999e-06*WS1' L=1.8e-7
MN_FA03_X1_11A sum03 p03 FA03_X1_n11 0 NM W='1.7999999999999999e-06*WS1' L=1.8e-7
MN_FA03_X1_11B FA03_X1_n11 c03 0 0 NM W='1.7999999999999999e-06*WS1' L=1.8e-7
MP_FA03_X1_01A sum03 p03 FA03_X1_p01 vdd PM W='3.5999999999999998e-06*WS1' L=1.8e-7
MP_FA03_X1_01B FA03_X1_p01 FA03_X1_bb vdd vdd PM W='3.5999999999999998e-06*WS1' L=1.8e-7
MP_FA03_X1_10A sum03 FA03_X1_ab FA03_X1_p10 vdd PM W='3.5999999999999998e-06*WS1' L=1.8e-7
MP_FA03_X1_10B FA03_X1_p10 c03 vdd vdd PM W='3.5999999999999998e-06*WS1' L=1.8e-7
MN_FA03_NAB_A nab03 a03 FA03_NAB_mid 0 NM W='2.3999999999999999e-06*WS2' L=1.8e-7
MN_FA03_NAB_B FA03_NAB_mid b03 0 0 NM W='2.3999999999999999e-06*WS2' L=1.8e-7
MP_FA03_NAB_A nab03 a03 vdd vdd PM W='4.7999999999999998e-06*WS2' L=1.8e-7
MP_FA03_NAB_B nab03 b03 vdd vdd PM W='4.7999999999999998e-06*WS2' L=1.8e-7
MN_FA03_NPC_A npc03 p03 FA03_NPC_mid 0 NM W='2.3999999999999999e-06*WS2' L=1.8e-7
MN_FA03_NPC_B FA03_NPC_mid c03 0 0 NM W='2.3999999999999999e-06*WS2' L=1.8e-7
MP_FA03_NPC_A npc03 p03 vdd vdd PM W='4.7999999999999998e-06*WS2' L=1.8e-7
MP_FA03_NPC_B npc03 c03 vdd vdd PM W='4.7999999999999998e-06*WS2' L=1.8e-7
MN_FA03_COUT_A c04 nab03 FA03_COUT_mid 0 NM W='7.9999999999999996e-06*WS3' L=1.8e-7
MN_FA03_COUT_B FA03_COUT_mid npc03 0 0 NM W='7.9999999999999996e-06*WS3' L=1.8e-7
MP_FA03_COUT_A c04 nab03 vdd vdd PM W='1.5999999999999999e-05*WS3' L=1.8e-7
MP_FA03_COUT_B c04 npc03 vdd vdd PM W='1.5999999999999999e-05*WS3' L=1.8e-7
MN_FA04_X0_IA FA04_X0_ab a04 0 0 NM W='1.1999999999999999e-06*WS0' L=1.8e-7
MP_FA04_X0_IA FA04_X0_ab a04 vdd vdd PM W='2.3999999999999999e-06*WS0' L=1.8e-7
MN_FA04_X0_IB FA04_X0_bb b04 0 0 NM W='1.1999999999999999e-06*WS0' L=1.8e-7
MP_FA04_X0_IB FA04_X0_bb b04 vdd vdd PM W='2.3999999999999999e-06*WS0' L=1.8e-7
MN_FA04_X0_00A p04 FA04_X0_ab FA04_X0_n00 0 NM W='1.7999999999999999e-06*WS1' L=1.8e-7
MN_FA04_X0_00B FA04_X0_n00 FA04_X0_bb 0 0 NM W='1.7999999999999999e-06*WS1' L=1.8e-7
MN_FA04_X0_11A p04 a04 FA04_X0_n11 0 NM W='1.7999999999999999e-06*WS1' L=1.8e-7
MN_FA04_X0_11B FA04_X0_n11 b04 0 0 NM W='1.7999999999999999e-06*WS1' L=1.8e-7
MP_FA04_X0_01A p04 a04 FA04_X0_p01 vdd PM W='3.5999999999999998e-06*WS1' L=1.8e-7
MP_FA04_X0_01B FA04_X0_p01 FA04_X0_bb vdd vdd PM W='3.5999999999999998e-06*WS1' L=1.8e-7
MP_FA04_X0_10A p04 FA04_X0_ab FA04_X0_p10 vdd PM W='3.5999999999999998e-06*WS1' L=1.8e-7
MP_FA04_X0_10B FA04_X0_p10 b04 vdd vdd PM W='3.5999999999999998e-06*WS1' L=1.8e-7
MN_FA04_X1_IA FA04_X1_ab p04 0 0 NM W='1.1999999999999999e-06*WS0' L=1.8e-7
MP_FA04_X1_IA FA04_X1_ab p04 vdd vdd PM W='2.3999999999999999e-06*WS0' L=1.8e-7
MN_FA04_X1_IB FA04_X1_bb c04 0 0 NM W='1.1999999999999999e-06*WS0' L=1.8e-7
MP_FA04_X1_IB FA04_X1_bb c04 vdd vdd PM W='2.3999999999999999e-06*WS0' L=1.8e-7
MN_FA04_X1_00A sum04 FA04_X1_ab FA04_X1_n00 0 NM W='1.7999999999999999e-06*WS1' L=1.8e-7
MN_FA04_X1_00B FA04_X1_n00 FA04_X1_bb 0 0 NM W='1.7999999999999999e-06*WS1' L=1.8e-7
MN_FA04_X1_11A sum04 p04 FA04_X1_n11 0 NM W='1.7999999999999999e-06*WS1' L=1.8e-7
MN_FA04_X1_11B FA04_X1_n11 c04 0 0 NM W='1.7999999999999999e-06*WS1' L=1.8e-7
MP_FA04_X1_01A sum04 p04 FA04_X1_p01 vdd PM W='3.5999999999999998e-06*WS1' L=1.8e-7
MP_FA04_X1_01B FA04_X1_p01 FA04_X1_bb vdd vdd PM W='3.5999999999999998e-06*WS1' L=1.8e-7
MP_FA04_X1_10A sum04 FA04_X1_ab FA04_X1_p10 vdd PM W='3.5999999999999998e-06*WS1' L=1.8e-7
MP_FA04_X1_10B FA04_X1_p10 c04 vdd vdd PM W='3.5999999999999998e-06*WS1' L=1.8e-7
MN_FA04_NAB_A nab04 a04 FA04_NAB_mid 0 NM W='2.3999999999999999e-06*WS2' L=1.8e-7
MN_FA04_NAB_B FA04_NAB_mid b04 0 0 NM W='2.3999999999999999e-06*WS2' L=1.8e-7
MP_FA04_NAB_A nab04 a04 vdd vdd PM W='4.7999999999999998e-06*WS2' L=1.8e-7
MP_FA04_NAB_B nab04 b04 vdd vdd PM W='4.7999999999999998e-06*WS2' L=1.8e-7
MN_FA04_NPC_A npc04 p04 FA04_NPC_mid 0 NM W='2.3999999999999999e-06*WS2' L=1.8e-7
MN_FA04_NPC_B FA04_NPC_mid c04 0 0 NM W='2.3999999999999999e-06*WS2' L=1.8e-7
MP_FA04_NPC_A npc04 p04 vdd vdd PM W='4.7999999999999998e-06*WS2' L=1.8e-7
MP_FA04_NPC_B npc04 c04 vdd vdd PM W='4.7999999999999998e-06*WS2' L=1.8e-7
MN_FA04_COUT_A c05 nab04 FA04_COUT_mid 0 NM W='7.9999999999999996e-06*WS3' L=1.8e-7
MN_FA04_COUT_B FA04_COUT_mid npc04 0 0 NM W='7.9999999999999996e-06*WS3' L=1.8e-7
MP_FA04_COUT_A c05 nab04 vdd vdd PM W='1.5999999999999999e-05*WS3' L=1.8e-7
MP_FA04_COUT_B c05 npc04 vdd vdd PM W='1.5999999999999999e-05*WS3' L=1.8e-7
MN_FA05_X0_IA FA05_X0_ab a05 0 0 NM W='1.1999999999999999e-06*WS0' L=1.8e-7
MP_FA05_X0_IA FA05_X0_ab a05 vdd vdd PM W='2.3999999999999999e-06*WS0' L=1.8e-7
MN_FA05_X0_IB FA05_X0_bb b05 0 0 NM W='1.1999999999999999e-06*WS0' L=1.8e-7
MP_FA05_X0_IB FA05_X0_bb b05 vdd vdd PM W='2.3999999999999999e-06*WS0' L=1.8e-7
MN_FA05_X0_00A p05 FA05_X0_ab FA05_X0_n00 0 NM W='1.7999999999999999e-06*WS1' L=1.8e-7
MN_FA05_X0_00B FA05_X0_n00 FA05_X0_bb 0 0 NM W='1.7999999999999999e-06*WS1' L=1.8e-7
MN_FA05_X0_11A p05 a05 FA05_X0_n11 0 NM W='1.7999999999999999e-06*WS1' L=1.8e-7
MN_FA05_X0_11B FA05_X0_n11 b05 0 0 NM W='1.7999999999999999e-06*WS1' L=1.8e-7
MP_FA05_X0_01A p05 a05 FA05_X0_p01 vdd PM W='3.5999999999999998e-06*WS1' L=1.8e-7
MP_FA05_X0_01B FA05_X0_p01 FA05_X0_bb vdd vdd PM W='3.5999999999999998e-06*WS1' L=1.8e-7
MP_FA05_X0_10A p05 FA05_X0_ab FA05_X0_p10 vdd PM W='3.5999999999999998e-06*WS1' L=1.8e-7
MP_FA05_X0_10B FA05_X0_p10 b05 vdd vdd PM W='3.5999999999999998e-06*WS1' L=1.8e-7
MN_FA05_X1_IA FA05_X1_ab p05 0 0 NM W='1.1999999999999999e-06*WS0' L=1.8e-7
MP_FA05_X1_IA FA05_X1_ab p05 vdd vdd PM W='2.3999999999999999e-06*WS0' L=1.8e-7
MN_FA05_X1_IB FA05_X1_bb c05 0 0 NM W='1.1999999999999999e-06*WS0' L=1.8e-7
MP_FA05_X1_IB FA05_X1_bb c05 vdd vdd PM W='2.3999999999999999e-06*WS0' L=1.8e-7
MN_FA05_X1_00A sum05 FA05_X1_ab FA05_X1_n00 0 NM W='1.7999999999999999e-06*WS1' L=1.8e-7
MN_FA05_X1_00B FA05_X1_n00 FA05_X1_bb 0 0 NM W='1.7999999999999999e-06*WS1' L=1.8e-7
MN_FA05_X1_11A sum05 p05 FA05_X1_n11 0 NM W='1.7999999999999999e-06*WS1' L=1.8e-7
MN_FA05_X1_11B FA05_X1_n11 c05 0 0 NM W='1.7999999999999999e-06*WS1' L=1.8e-7
MP_FA05_X1_01A sum05 p05 FA05_X1_p01 vdd PM W='3.5999999999999998e-06*WS1' L=1.8e-7
MP_FA05_X1_01B FA05_X1_p01 FA05_X1_bb vdd vdd PM W='3.5999999999999998e-06*WS1' L=1.8e-7
MP_FA05_X1_10A sum05 FA05_X1_ab FA05_X1_p10 vdd PM W='3.5999999999999998e-06*WS1' L=1.8e-7
MP_FA05_X1_10B FA05_X1_p10 c05 vdd vdd PM W='3.5999999999999998e-06*WS1' L=1.8e-7
MN_FA05_NAB_A nab05 a05 FA05_NAB_mid 0 NM W='2.3999999999999999e-06*WS2' L=1.8e-7
MN_FA05_NAB_B FA05_NAB_mid b05 0 0 NM W='2.3999999999999999e-06*WS2' L=1.8e-7
MP_FA05_NAB_A nab05 a05 vdd vdd PM W='4.7999999999999998e-06*WS2' L=1.8e-7
MP_FA05_NAB_B nab05 b05 vdd vdd PM W='4.7999999999999998e-06*WS2' L=1.8e-7
MN_FA05_NPC_A npc05 p05 FA05_NPC_mid 0 NM W='2.3999999999999999e-06*WS2' L=1.8e-7
MN_FA05_NPC_B FA05_NPC_mid c05 0 0 NM W='2.3999999999999999e-06*WS2' L=1.8e-7
MP_FA05_NPC_A npc05 p05 vdd vdd PM W='4.7999999999999998e-06*WS2' L=1.8e-7
MP_FA05_NPC_B npc05 c05 vdd vdd PM W='4.7999999999999998e-06*WS2' L=1.8e-7
MN_FA05_COUT_A c06 nab05 FA05_COUT_mid 0 NM W='7.9999999999999996e-06*WS3' L=1.8e-7
MN_FA05_COUT_B FA05_COUT_mid npc05 0 0 NM W='7.9999999999999996e-06*WS3' L=1.8e-7
MP_FA05_COUT_A c06 nab05 vdd vdd PM W='1.5999999999999999e-05*WS3' L=1.8e-7
MP_FA05_COUT_B c06 npc05 vdd vdd PM W='1.5999999999999999e-05*WS3' L=1.8e-7
MN_FA06_X0_IA FA06_X0_ab a06 0 0 NM W='1.1999999999999999e-06*WS0' L=1.8e-7
MP_FA06_X0_IA FA06_X0_ab a06 vdd vdd PM W='2.3999999999999999e-06*WS0' L=1.8e-7
MN_FA06_X0_IB FA06_X0_bb b06 0 0 NM W='1.1999999999999999e-06*WS0' L=1.8e-7
MP_FA06_X0_IB FA06_X0_bb b06 vdd vdd PM W='2.3999999999999999e-06*WS0' L=1.8e-7
MN_FA06_X0_00A p06 FA06_X0_ab FA06_X0_n00 0 NM W='1.7999999999999999e-06*WS1' L=1.8e-7
MN_FA06_X0_00B FA06_X0_n00 FA06_X0_bb 0 0 NM W='1.7999999999999999e-06*WS1' L=1.8e-7
MN_FA06_X0_11A p06 a06 FA06_X0_n11 0 NM W='1.7999999999999999e-06*WS1' L=1.8e-7
MN_FA06_X0_11B FA06_X0_n11 b06 0 0 NM W='1.7999999999999999e-06*WS1' L=1.8e-7
MP_FA06_X0_01A p06 a06 FA06_X0_p01 vdd PM W='3.5999999999999998e-06*WS1' L=1.8e-7
MP_FA06_X0_01B FA06_X0_p01 FA06_X0_bb vdd vdd PM W='3.5999999999999998e-06*WS1' L=1.8e-7
MP_FA06_X0_10A p06 FA06_X0_ab FA06_X0_p10 vdd PM W='3.5999999999999998e-06*WS1' L=1.8e-7
MP_FA06_X0_10B FA06_X0_p10 b06 vdd vdd PM W='3.5999999999999998e-06*WS1' L=1.8e-7
MN_FA06_X1_IA FA06_X1_ab p06 0 0 NM W='1.1999999999999999e-06*WS0' L=1.8e-7
MP_FA06_X1_IA FA06_X1_ab p06 vdd vdd PM W='2.3999999999999999e-06*WS0' L=1.8e-7
MN_FA06_X1_IB FA06_X1_bb c06 0 0 NM W='1.1999999999999999e-06*WS0' L=1.8e-7
MP_FA06_X1_IB FA06_X1_bb c06 vdd vdd PM W='2.3999999999999999e-06*WS0' L=1.8e-7
MN_FA06_X1_00A sum06 FA06_X1_ab FA06_X1_n00 0 NM W='1.7999999999999999e-06*WS1' L=1.8e-7
MN_FA06_X1_00B FA06_X1_n00 FA06_X1_bb 0 0 NM W='1.7999999999999999e-06*WS1' L=1.8e-7
MN_FA06_X1_11A sum06 p06 FA06_X1_n11 0 NM W='1.7999999999999999e-06*WS1' L=1.8e-7
MN_FA06_X1_11B FA06_X1_n11 c06 0 0 NM W='1.7999999999999999e-06*WS1' L=1.8e-7
MP_FA06_X1_01A sum06 p06 FA06_X1_p01 vdd PM W='3.5999999999999998e-06*WS1' L=1.8e-7
MP_FA06_X1_01B FA06_X1_p01 FA06_X1_bb vdd vdd PM W='3.5999999999999998e-06*WS1' L=1.8e-7
MP_FA06_X1_10A sum06 FA06_X1_ab FA06_X1_p10 vdd PM W='3.5999999999999998e-06*WS1' L=1.8e-7
MP_FA06_X1_10B FA06_X1_p10 c06 vdd vdd PM W='3.5999999999999998e-06*WS1' L=1.8e-7
MN_FA06_NAB_A nab06 a06 FA06_NAB_mid 0 NM W='2.3999999999999999e-06*WS2' L=1.8e-7
MN_FA06_NAB_B FA06_NAB_mid b06 0 0 NM W='2.3999999999999999e-06*WS2' L=1.8e-7
MP_FA06_NAB_A nab06 a06 vdd vdd PM W='4.7999999999999998e-06*WS2' L=1.8e-7
MP_FA06_NAB_B nab06 b06 vdd vdd PM W='4.7999999999999998e-06*WS2' L=1.8e-7
MN_FA06_NPC_A npc06 p06 FA06_NPC_mid 0 NM W='2.3999999999999999e-06*WS2' L=1.8e-7
MN_FA06_NPC_B FA06_NPC_mid c06 0 0 NM W='2.3999999999999999e-06*WS2' L=1.8e-7
MP_FA06_NPC_A npc06 p06 vdd vdd PM W='4.7999999999999998e-06*WS2' L=1.8e-7
MP_FA06_NPC_B npc06 c06 vdd vdd PM W='4.7999999999999998e-06*WS2' L=1.8e-7
MN_FA06_COUT_A c07 nab06 FA06_COUT_mid 0 NM W='7.9999999999999996e-06*WS3' L=1.8e-7
MN_FA06_COUT_B FA06_COUT_mid npc06 0 0 NM W='7.9999999999999996e-06*WS3' L=1.8e-7
MP_FA06_COUT_A c07 nab06 vdd vdd PM W='1.5999999999999999e-05*WS3' L=1.8e-7
MP_FA06_COUT_B c07 npc06 vdd vdd PM W='1.5999999999999999e-05*WS3' L=1.8e-7
MN_FA07_X0_IA FA07_X0_ab a07 0 0 NM W='1.1999999999999999e-06*WS0' L=1.8e-7
MP_FA07_X0_IA FA07_X0_ab a07 vdd vdd PM W='2.3999999999999999e-06*WS0' L=1.8e-7
MN_FA07_X0_IB FA07_X0_bb b07 0 0 NM W='1.1999999999999999e-06*WS0' L=1.8e-7
MP_FA07_X0_IB FA07_X0_bb b07 vdd vdd PM W='2.3999999999999999e-06*WS0' L=1.8e-7
MN_FA07_X0_00A p07 FA07_X0_ab FA07_X0_n00 0 NM W='1.7999999999999999e-06*WS1' L=1.8e-7
MN_FA07_X0_00B FA07_X0_n00 FA07_X0_bb 0 0 NM W='1.7999999999999999e-06*WS1' L=1.8e-7
MN_FA07_X0_11A p07 a07 FA07_X0_n11 0 NM W='1.7999999999999999e-06*WS1' L=1.8e-7
MN_FA07_X0_11B FA07_X0_n11 b07 0 0 NM W='1.7999999999999999e-06*WS1' L=1.8e-7
MP_FA07_X0_01A p07 a07 FA07_X0_p01 vdd PM W='3.5999999999999998e-06*WS1' L=1.8e-7
MP_FA07_X0_01B FA07_X0_p01 FA07_X0_bb vdd vdd PM W='3.5999999999999998e-06*WS1' L=1.8e-7
MP_FA07_X0_10A p07 FA07_X0_ab FA07_X0_p10 vdd PM W='3.5999999999999998e-06*WS1' L=1.8e-7
MP_FA07_X0_10B FA07_X0_p10 b07 vdd vdd PM W='3.5999999999999998e-06*WS1' L=1.8e-7
MN_FA07_X1_IA FA07_X1_ab p07 0 0 NM W='1.1999999999999999e-06*WS0' L=1.8e-7
MP_FA07_X1_IA FA07_X1_ab p07 vdd vdd PM W='2.3999999999999999e-06*WS0' L=1.8e-7
MN_FA07_X1_IB FA07_X1_bb c07 0 0 NM W='1.1999999999999999e-06*WS0' L=1.8e-7
MP_FA07_X1_IB FA07_X1_bb c07 vdd vdd PM W='2.3999999999999999e-06*WS0' L=1.8e-7
MN_FA07_X1_00A sum07 FA07_X1_ab FA07_X1_n00 0 NM W='1.7999999999999999e-06*WS1' L=1.8e-7
MN_FA07_X1_00B FA07_X1_n00 FA07_X1_bb 0 0 NM W='1.7999999999999999e-06*WS1' L=1.8e-7
MN_FA07_X1_11A sum07 p07 FA07_X1_n11 0 NM W='1.7999999999999999e-06*WS1' L=1.8e-7
MN_FA07_X1_11B FA07_X1_n11 c07 0 0 NM W='1.7999999999999999e-06*WS1' L=1.8e-7
MP_FA07_X1_01A sum07 p07 FA07_X1_p01 vdd PM W='3.5999999999999998e-06*WS1' L=1.8e-7
MP_FA07_X1_01B FA07_X1_p01 FA07_X1_bb vdd vdd PM W='3.5999999999999998e-06*WS1' L=1.8e-7
MP_FA07_X1_10A sum07 FA07_X1_ab FA07_X1_p10 vdd PM W='3.5999999999999998e-06*WS1' L=1.8e-7
MP_FA07_X1_10B FA07_X1_p10 c07 vdd vdd PM W='3.5999999999999998e-06*WS1' L=1.8e-7
MN_FA07_NAB_A nab07 a07 FA07_NAB_mid 0 NM W='2.3999999999999999e-06*WS2' L=1.8e-7
MN_FA07_NAB_B FA07_NAB_mid b07 0 0 NM W='2.3999999999999999e-06*WS2' L=1.8e-7
MP_FA07_NAB_A nab07 a07 vdd vdd PM W='4.7999999999999998e-06*WS2' L=1.8e-7
MP_FA07_NAB_B nab07 b07 vdd vdd PM W='4.7999999999999998e-06*WS2' L=1.8e-7
MN_FA07_NPC_A npc07 p07 FA07_NPC_mid 0 NM W='2.3999999999999999e-06*WS2' L=1.8e-7
MN_FA07_NPC_B FA07_NPC_mid c07 0 0 NM W='2.3999999999999999e-06*WS2' L=1.8e-7
MP_FA07_NPC_A npc07 p07 vdd vdd PM W='4.7999999999999998e-06*WS2' L=1.8e-7
MP_FA07_NPC_B npc07 c07 vdd vdd PM W='4.7999999999999998e-06*WS2' L=1.8e-7
MN_FA07_COUT_A c08 nab07 FA07_COUT_mid 0 NM W='7.9999999999999996e-06*WS3' L=1.8e-7
MN_FA07_COUT_B FA07_COUT_mid npc07 0 0 NM W='7.9999999999999996e-06*WS3' L=1.8e-7
MP_FA07_COUT_A c08 nab07 vdd vdd PM W='1.5999999999999999e-05*WS3' L=1.8e-7
MP_FA07_COUT_B c08 npc07 vdd vdd PM W='1.5999999999999999e-05*WS3' L=1.8e-7
MN_FA08_X0_IA FA08_X0_ab a08 0 0 NM W='1.1999999999999999e-06*WS0' L=1.8e-7
MP_FA08_X0_IA FA08_X0_ab a08 vdd vdd PM W='2.3999999999999999e-06*WS0' L=1.8e-7
MN_FA08_X0_IB FA08_X0_bb b08 0 0 NM W='1.1999999999999999e-06*WS0' L=1.8e-7
MP_FA08_X0_IB FA08_X0_bb b08 vdd vdd PM W='2.3999999999999999e-06*WS0' L=1.8e-7
MN_FA08_X0_00A p08 FA08_X0_ab FA08_X0_n00 0 NM W='1.7999999999999999e-06*WS1' L=1.8e-7
MN_FA08_X0_00B FA08_X0_n00 FA08_X0_bb 0 0 NM W='1.7999999999999999e-06*WS1' L=1.8e-7
MN_FA08_X0_11A p08 a08 FA08_X0_n11 0 NM W='1.7999999999999999e-06*WS1' L=1.8e-7
MN_FA08_X0_11B FA08_X0_n11 b08 0 0 NM W='1.7999999999999999e-06*WS1' L=1.8e-7
MP_FA08_X0_01A p08 a08 FA08_X0_p01 vdd PM W='3.5999999999999998e-06*WS1' L=1.8e-7
MP_FA08_X0_01B FA08_X0_p01 FA08_X0_bb vdd vdd PM W='3.5999999999999998e-06*WS1' L=1.8e-7
MP_FA08_X0_10A p08 FA08_X0_ab FA08_X0_p10 vdd PM W='3.5999999999999998e-06*WS1' L=1.8e-7
MP_FA08_X0_10B FA08_X0_p10 b08 vdd vdd PM W='3.5999999999999998e-06*WS1' L=1.8e-7
MN_FA08_X1_IA FA08_X1_ab p08 0 0 NM W='1.1999999999999999e-06*WS0' L=1.8e-7
MP_FA08_X1_IA FA08_X1_ab p08 vdd vdd PM W='2.3999999999999999e-06*WS0' L=1.8e-7
MN_FA08_X1_IB FA08_X1_bb c08 0 0 NM W='1.1999999999999999e-06*WS0' L=1.8e-7
MP_FA08_X1_IB FA08_X1_bb c08 vdd vdd PM W='2.3999999999999999e-06*WS0' L=1.8e-7
MN_FA08_X1_00A sum08 FA08_X1_ab FA08_X1_n00 0 NM W='1.7999999999999999e-06*WS1' L=1.8e-7
MN_FA08_X1_00B FA08_X1_n00 FA08_X1_bb 0 0 NM W='1.7999999999999999e-06*WS1' L=1.8e-7
MN_FA08_X1_11A sum08 p08 FA08_X1_n11 0 NM W='1.7999999999999999e-06*WS1' L=1.8e-7
MN_FA08_X1_11B FA08_X1_n11 c08 0 0 NM W='1.7999999999999999e-06*WS1' L=1.8e-7
MP_FA08_X1_01A sum08 p08 FA08_X1_p01 vdd PM W='3.5999999999999998e-06*WS1' L=1.8e-7
MP_FA08_X1_01B FA08_X1_p01 FA08_X1_bb vdd vdd PM W='3.5999999999999998e-06*WS1' L=1.8e-7
MP_FA08_X1_10A sum08 FA08_X1_ab FA08_X1_p10 vdd PM W='3.5999999999999998e-06*WS1' L=1.8e-7
MP_FA08_X1_10B FA08_X1_p10 c08 vdd vdd PM W='3.5999999999999998e-06*WS1' L=1.8e-7
MN_FA08_NAB_A nab08 a08 FA08_NAB_mid 0 NM W='2.3999999999999999e-06*WS2' L=1.8e-7
MN_FA08_NAB_B FA08_NAB_mid b08 0 0 NM W='2.3999999999999999e-06*WS2' L=1.8e-7
MP_FA08_NAB_A nab08 a08 vdd vdd PM W='4.7999999999999998e-06*WS2' L=1.8e-7
MP_FA08_NAB_B nab08 b08 vdd vdd PM W='4.7999999999999998e-06*WS2' L=1.8e-7
MN_FA08_NPC_A npc08 p08 FA08_NPC_mid 0 NM W='2.3999999999999999e-06*WS2' L=1.8e-7
MN_FA08_NPC_B FA08_NPC_mid c08 0 0 NM W='2.3999999999999999e-06*WS2' L=1.8e-7
MP_FA08_NPC_A npc08 p08 vdd vdd PM W='4.7999999999999998e-06*WS2' L=1.8e-7
MP_FA08_NPC_B npc08 c08 vdd vdd PM W='4.7999999999999998e-06*WS2' L=1.8e-7
MN_FA08_COUT_A c09 nab08 FA08_COUT_mid 0 NM W='7.9999999999999996e-06*WS3' L=1.8e-7
MN_FA08_COUT_B FA08_COUT_mid npc08 0 0 NM W='7.9999999999999996e-06*WS3' L=1.8e-7
MP_FA08_COUT_A c09 nab08 vdd vdd PM W='1.5999999999999999e-05*WS3' L=1.8e-7
MP_FA08_COUT_B c09 npc08 vdd vdd PM W='1.5999999999999999e-05*WS3' L=1.8e-7
MN_FA09_X0_IA FA09_X0_ab a09 0 0 NM W='1.1999999999999999e-06*WS0' L=1.8e-7
MP_FA09_X0_IA FA09_X0_ab a09 vdd vdd PM W='2.3999999999999999e-06*WS0' L=1.8e-7
MN_FA09_X0_IB FA09_X0_bb b09 0 0 NM W='1.1999999999999999e-06*WS0' L=1.8e-7
MP_FA09_X0_IB FA09_X0_bb b09 vdd vdd PM W='2.3999999999999999e-06*WS0' L=1.8e-7
MN_FA09_X0_00A p09 FA09_X0_ab FA09_X0_n00 0 NM W='1.7999999999999999e-06*WS1' L=1.8e-7
MN_FA09_X0_00B FA09_X0_n00 FA09_X0_bb 0 0 NM W='1.7999999999999999e-06*WS1' L=1.8e-7
MN_FA09_X0_11A p09 a09 FA09_X0_n11 0 NM W='1.7999999999999999e-06*WS1' L=1.8e-7
MN_FA09_X0_11B FA09_X0_n11 b09 0 0 NM W='1.7999999999999999e-06*WS1' L=1.8e-7
MP_FA09_X0_01A p09 a09 FA09_X0_p01 vdd PM W='3.5999999999999998e-06*WS1' L=1.8e-7
MP_FA09_X0_01B FA09_X0_p01 FA09_X0_bb vdd vdd PM W='3.5999999999999998e-06*WS1' L=1.8e-7
MP_FA09_X0_10A p09 FA09_X0_ab FA09_X0_p10 vdd PM W='3.5999999999999998e-06*WS1' L=1.8e-7
MP_FA09_X0_10B FA09_X0_p10 b09 vdd vdd PM W='3.5999999999999998e-06*WS1' L=1.8e-7
MN_FA09_X1_IA FA09_X1_ab p09 0 0 NM W='1.1999999999999999e-06*WS0' L=1.8e-7
MP_FA09_X1_IA FA09_X1_ab p09 vdd vdd PM W='2.3999999999999999e-06*WS0' L=1.8e-7
MN_FA09_X1_IB FA09_X1_bb c09 0 0 NM W='1.1999999999999999e-06*WS0' L=1.8e-7
MP_FA09_X1_IB FA09_X1_bb c09 vdd vdd PM W='2.3999999999999999e-06*WS0' L=1.8e-7
MN_FA09_X1_00A sum09 FA09_X1_ab FA09_X1_n00 0 NM W='1.7999999999999999e-06*WS1' L=1.8e-7
MN_FA09_X1_00B FA09_X1_n00 FA09_X1_bb 0 0 NM W='1.7999999999999999e-06*WS1' L=1.8e-7
MN_FA09_X1_11A sum09 p09 FA09_X1_n11 0 NM W='1.7999999999999999e-06*WS1' L=1.8e-7
MN_FA09_X1_11B FA09_X1_n11 c09 0 0 NM W='1.7999999999999999e-06*WS1' L=1.8e-7
MP_FA09_X1_01A sum09 p09 FA09_X1_p01 vdd PM W='3.5999999999999998e-06*WS1' L=1.8e-7
MP_FA09_X1_01B FA09_X1_p01 FA09_X1_bb vdd vdd PM W='3.5999999999999998e-06*WS1' L=1.8e-7
MP_FA09_X1_10A sum09 FA09_X1_ab FA09_X1_p10 vdd PM W='3.5999999999999998e-06*WS1' L=1.8e-7
MP_FA09_X1_10B FA09_X1_p10 c09 vdd vdd PM W='3.5999999999999998e-06*WS1' L=1.8e-7
MN_FA09_NAB_A nab09 a09 FA09_NAB_mid 0 NM W='2.3999999999999999e-06*WS2' L=1.8e-7
MN_FA09_NAB_B FA09_NAB_mid b09 0 0 NM W='2.3999999999999999e-06*WS2' L=1.8e-7
MP_FA09_NAB_A nab09 a09 vdd vdd PM W='4.7999999999999998e-06*WS2' L=1.8e-7
MP_FA09_NAB_B nab09 b09 vdd vdd PM W='4.7999999999999998e-06*WS2' L=1.8e-7
MN_FA09_NPC_A npc09 p09 FA09_NPC_mid 0 NM W='2.3999999999999999e-06*WS2' L=1.8e-7
MN_FA09_NPC_B FA09_NPC_mid c09 0 0 NM W='2.3999999999999999e-06*WS2' L=1.8e-7
MP_FA09_NPC_A npc09 p09 vdd vdd PM W='4.7999999999999998e-06*WS2' L=1.8e-7
MP_FA09_NPC_B npc09 c09 vdd vdd PM W='4.7999999999999998e-06*WS2' L=1.8e-7
MN_FA09_COUT_A c10 nab09 FA09_COUT_mid 0 NM W='7.9999999999999996e-06*WS3' L=1.8e-7
MN_FA09_COUT_B FA09_COUT_mid npc09 0 0 NM W='7.9999999999999996e-06*WS3' L=1.8e-7
MP_FA09_COUT_A c10 nab09 vdd vdd PM W='1.5999999999999999e-05*WS3' L=1.8e-7
MP_FA09_COUT_B c10 npc09 vdd vdd PM W='1.5999999999999999e-05*WS3' L=1.8e-7
MN_FA10_X0_IA FA10_X0_ab a10 0 0 NM W='1.1999999999999999e-06*WS0' L=1.8e-7
MP_FA10_X0_IA FA10_X0_ab a10 vdd vdd PM W='2.3999999999999999e-06*WS0' L=1.8e-7
MN_FA10_X0_IB FA10_X0_bb b10 0 0 NM W='1.1999999999999999e-06*WS0' L=1.8e-7
MP_FA10_X0_IB FA10_X0_bb b10 vdd vdd PM W='2.3999999999999999e-06*WS0' L=1.8e-7
MN_FA10_X0_00A p10 FA10_X0_ab FA10_X0_n00 0 NM W='1.7999999999999999e-06*WS1' L=1.8e-7
MN_FA10_X0_00B FA10_X0_n00 FA10_X0_bb 0 0 NM W='1.7999999999999999e-06*WS1' L=1.8e-7
MN_FA10_X0_11A p10 a10 FA10_X0_n11 0 NM W='1.7999999999999999e-06*WS1' L=1.8e-7
MN_FA10_X0_11B FA10_X0_n11 b10 0 0 NM W='1.7999999999999999e-06*WS1' L=1.8e-7
MP_FA10_X0_01A p10 a10 FA10_X0_p01 vdd PM W='3.5999999999999998e-06*WS1' L=1.8e-7
MP_FA10_X0_01B FA10_X0_p01 FA10_X0_bb vdd vdd PM W='3.5999999999999998e-06*WS1' L=1.8e-7
MP_FA10_X0_10A p10 FA10_X0_ab FA10_X0_p10 vdd PM W='3.5999999999999998e-06*WS1' L=1.8e-7
MP_FA10_X0_10B FA10_X0_p10 b10 vdd vdd PM W='3.5999999999999998e-06*WS1' L=1.8e-7
MN_FA10_X1_IA FA10_X1_ab p10 0 0 NM W='1.1999999999999999e-06*WS0' L=1.8e-7
MP_FA10_X1_IA FA10_X1_ab p10 vdd vdd PM W='2.3999999999999999e-06*WS0' L=1.8e-7
MN_FA10_X1_IB FA10_X1_bb c10 0 0 NM W='1.1999999999999999e-06*WS0' L=1.8e-7
MP_FA10_X1_IB FA10_X1_bb c10 vdd vdd PM W='2.3999999999999999e-06*WS0' L=1.8e-7
MN_FA10_X1_00A sum10 FA10_X1_ab FA10_X1_n00 0 NM W='1.7999999999999999e-06*WS1' L=1.8e-7
MN_FA10_X1_00B FA10_X1_n00 FA10_X1_bb 0 0 NM W='1.7999999999999999e-06*WS1' L=1.8e-7
MN_FA10_X1_11A sum10 p10 FA10_X1_n11 0 NM W='1.7999999999999999e-06*WS1' L=1.8e-7
MN_FA10_X1_11B FA10_X1_n11 c10 0 0 NM W='1.7999999999999999e-06*WS1' L=1.8e-7
MP_FA10_X1_01A sum10 p10 FA10_X1_p01 vdd PM W='3.5999999999999998e-06*WS1' L=1.8e-7
MP_FA10_X1_01B FA10_X1_p01 FA10_X1_bb vdd vdd PM W='3.5999999999999998e-06*WS1' L=1.8e-7
MP_FA10_X1_10A sum10 FA10_X1_ab FA10_X1_p10 vdd PM W='3.5999999999999998e-06*WS1' L=1.8e-7
MP_FA10_X1_10B FA10_X1_p10 c10 vdd vdd PM W='3.5999999999999998e-06*WS1' L=1.8e-7
MN_FA10_NAB_A nab10 a10 FA10_NAB_mid 0 NM W='2.3999999999999999e-06*WS2' L=1.8e-7
MN_FA10_NAB_B FA10_NAB_mid b10 0 0 NM W='2.3999999999999999e-06*WS2' L=1.8e-7
MP_FA10_NAB_A nab10 a10 vdd vdd PM W='4.7999999999999998e-06*WS2' L=1.8e-7
MP_FA10_NAB_B nab10 b10 vdd vdd PM W='4.7999999999999998e-06*WS2' L=1.8e-7
MN_FA10_NPC_A npc10 p10 FA10_NPC_mid 0 NM W='2.3999999999999999e-06*WS2' L=1.8e-7
MN_FA10_NPC_B FA10_NPC_mid c10 0 0 NM W='2.3999999999999999e-06*WS2' L=1.8e-7
MP_FA10_NPC_A npc10 p10 vdd vdd PM W='4.7999999999999998e-06*WS2' L=1.8e-7
MP_FA10_NPC_B npc10 c10 vdd vdd PM W='4.7999999999999998e-06*WS2' L=1.8e-7
MN_FA10_COUT_A c11 nab10 FA10_COUT_mid 0 NM W='7.9999999999999996e-06*WS3' L=1.8e-7
MN_FA10_COUT_B FA10_COUT_mid npc10 0 0 NM W='7.9999999999999996e-06*WS3' L=1.8e-7
MP_FA10_COUT_A c11 nab10 vdd vdd PM W='1.5999999999999999e-05*WS3' L=1.8e-7
MP_FA10_COUT_B c11 npc10 vdd vdd PM W='1.5999999999999999e-05*WS3' L=1.8e-7
MN_FA11_X0_IA FA11_X0_ab a11 0 0 NM W='1.1999999999999999e-06*WS0' L=1.8e-7
MP_FA11_X0_IA FA11_X0_ab a11 vdd vdd PM W='2.3999999999999999e-06*WS0' L=1.8e-7
MN_FA11_X0_IB FA11_X0_bb b11 0 0 NM W='1.1999999999999999e-06*WS0' L=1.8e-7
MP_FA11_X0_IB FA11_X0_bb b11 vdd vdd PM W='2.3999999999999999e-06*WS0' L=1.8e-7
MN_FA11_X0_00A p11 FA11_X0_ab FA11_X0_n00 0 NM W='1.7999999999999999e-06*WS1' L=1.8e-7
MN_FA11_X0_00B FA11_X0_n00 FA11_X0_bb 0 0 NM W='1.7999999999999999e-06*WS1' L=1.8e-7
MN_FA11_X0_11A p11 a11 FA11_X0_n11 0 NM W='1.7999999999999999e-06*WS1' L=1.8e-7
MN_FA11_X0_11B FA11_X0_n11 b11 0 0 NM W='1.7999999999999999e-06*WS1' L=1.8e-7
MP_FA11_X0_01A p11 a11 FA11_X0_p01 vdd PM W='3.5999999999999998e-06*WS1' L=1.8e-7
MP_FA11_X0_01B FA11_X0_p01 FA11_X0_bb vdd vdd PM W='3.5999999999999998e-06*WS1' L=1.8e-7
MP_FA11_X0_10A p11 FA11_X0_ab FA11_X0_p10 vdd PM W='3.5999999999999998e-06*WS1' L=1.8e-7
MP_FA11_X0_10B FA11_X0_p10 b11 vdd vdd PM W='3.5999999999999998e-06*WS1' L=1.8e-7
MN_FA11_X1_IA FA11_X1_ab p11 0 0 NM W='1.1999999999999999e-06*WS0' L=1.8e-7
MP_FA11_X1_IA FA11_X1_ab p11 vdd vdd PM W='2.3999999999999999e-06*WS0' L=1.8e-7
MN_FA11_X1_IB FA11_X1_bb c11 0 0 NM W='1.1999999999999999e-06*WS0' L=1.8e-7
MP_FA11_X1_IB FA11_X1_bb c11 vdd vdd PM W='2.3999999999999999e-06*WS0' L=1.8e-7
MN_FA11_X1_00A sum11 FA11_X1_ab FA11_X1_n00 0 NM W='1.7999999999999999e-06*WS1' L=1.8e-7
MN_FA11_X1_00B FA11_X1_n00 FA11_X1_bb 0 0 NM W='1.7999999999999999e-06*WS1' L=1.8e-7
MN_FA11_X1_11A sum11 p11 FA11_X1_n11 0 NM W='1.7999999999999999e-06*WS1' L=1.8e-7
MN_FA11_X1_11B FA11_X1_n11 c11 0 0 NM W='1.7999999999999999e-06*WS1' L=1.8e-7
MP_FA11_X1_01A sum11 p11 FA11_X1_p01 vdd PM W='3.5999999999999998e-06*WS1' L=1.8e-7
MP_FA11_X1_01B FA11_X1_p01 FA11_X1_bb vdd vdd PM W='3.5999999999999998e-06*WS1' L=1.8e-7
MP_FA11_X1_10A sum11 FA11_X1_ab FA11_X1_p10 vdd PM W='3.5999999999999998e-06*WS1' L=1.8e-7
MP_FA11_X1_10B FA11_X1_p10 c11 vdd vdd PM W='3.5999999999999998e-06*WS1' L=1.8e-7
MN_FA11_NAB_A nab11 a11 FA11_NAB_mid 0 NM W='2.3999999999999999e-06*WS2' L=1.8e-7
MN_FA11_NAB_B FA11_NAB_mid b11 0 0 NM W='2.3999999999999999e-06*WS2' L=1.8e-7
MP_FA11_NAB_A nab11 a11 vdd vdd PM W='4.7999999999999998e-06*WS2' L=1.8e-7
MP_FA11_NAB_B nab11 b11 vdd vdd PM W='4.7999999999999998e-06*WS2' L=1.8e-7
MN_FA11_NPC_A npc11 p11 FA11_NPC_mid 0 NM W='2.3999999999999999e-06*WS2' L=1.8e-7
MN_FA11_NPC_B FA11_NPC_mid c11 0 0 NM W='2.3999999999999999e-06*WS2' L=1.8e-7
MP_FA11_NPC_A npc11 p11 vdd vdd PM W='4.7999999999999998e-06*WS2' L=1.8e-7
MP_FA11_NPC_B npc11 c11 vdd vdd PM W='4.7999999999999998e-06*WS2' L=1.8e-7
MN_FA11_COUT_A c12 nab11 FA11_COUT_mid 0 NM W='7.9999999999999996e-06*WS3' L=1.8e-7
MN_FA11_COUT_B FA11_COUT_mid npc11 0 0 NM W='7.9999999999999996e-06*WS3' L=1.8e-7
MP_FA11_COUT_A c12 nab11 vdd vdd PM W='1.5999999999999999e-05*WS3' L=1.8e-7
MP_FA11_COUT_B c12 npc11 vdd vdd PM W='1.5999999999999999e-05*WS3' L=1.8e-7
MN_FA12_X0_IA FA12_X0_ab a12 0 0 NM W='1.1999999999999999e-06*WS0' L=1.8e-7
MP_FA12_X0_IA FA12_X0_ab a12 vdd vdd PM W='2.3999999999999999e-06*WS0' L=1.8e-7
MN_FA12_X0_IB FA12_X0_bb b12 0 0 NM W='1.1999999999999999e-06*WS0' L=1.8e-7
MP_FA12_X0_IB FA12_X0_bb b12 vdd vdd PM W='2.3999999999999999e-06*WS0' L=1.8e-7
MN_FA12_X0_00A p12 FA12_X0_ab FA12_X0_n00 0 NM W='1.7999999999999999e-06*WS1' L=1.8e-7
MN_FA12_X0_00B FA12_X0_n00 FA12_X0_bb 0 0 NM W='1.7999999999999999e-06*WS1' L=1.8e-7
MN_FA12_X0_11A p12 a12 FA12_X0_n11 0 NM W='1.7999999999999999e-06*WS1' L=1.8e-7
MN_FA12_X0_11B FA12_X0_n11 b12 0 0 NM W='1.7999999999999999e-06*WS1' L=1.8e-7
MP_FA12_X0_01A p12 a12 FA12_X0_p01 vdd PM W='3.5999999999999998e-06*WS1' L=1.8e-7
MP_FA12_X0_01B FA12_X0_p01 FA12_X0_bb vdd vdd PM W='3.5999999999999998e-06*WS1' L=1.8e-7
MP_FA12_X0_10A p12 FA12_X0_ab FA12_X0_p10 vdd PM W='3.5999999999999998e-06*WS1' L=1.8e-7
MP_FA12_X0_10B FA12_X0_p10 b12 vdd vdd PM W='3.5999999999999998e-06*WS1' L=1.8e-7
MN_FA12_X1_IA FA12_X1_ab p12 0 0 NM W='1.1999999999999999e-06*WS0' L=1.8e-7
MP_FA12_X1_IA FA12_X1_ab p12 vdd vdd PM W='2.3999999999999999e-06*WS0' L=1.8e-7
MN_FA12_X1_IB FA12_X1_bb c12 0 0 NM W='1.1999999999999999e-06*WS0' L=1.8e-7
MP_FA12_X1_IB FA12_X1_bb c12 vdd vdd PM W='2.3999999999999999e-06*WS0' L=1.8e-7
MN_FA12_X1_00A sum12 FA12_X1_ab FA12_X1_n00 0 NM W='1.7999999999999999e-06*WS1' L=1.8e-7
MN_FA12_X1_00B FA12_X1_n00 FA12_X1_bb 0 0 NM W='1.7999999999999999e-06*WS1' L=1.8e-7
MN_FA12_X1_11A sum12 p12 FA12_X1_n11 0 NM W='1.7999999999999999e-06*WS1' L=1.8e-7
MN_FA12_X1_11B FA12_X1_n11 c12 0 0 NM W='1.7999999999999999e-06*WS1' L=1.8e-7
MP_FA12_X1_01A sum12 p12 FA12_X1_p01 vdd PM W='3.5999999999999998e-06*WS1' L=1.8e-7
MP_FA12_X1_01B FA12_X1_p01 FA12_X1_bb vdd vdd PM W='3.5999999999999998e-06*WS1' L=1.8e-7
MP_FA12_X1_10A sum12 FA12_X1_ab FA12_X1_p10 vdd PM W='3.5999999999999998e-06*WS1' L=1.8e-7
MP_FA12_X1_10B FA12_X1_p10 c12 vdd vdd PM W='3.5999999999999998e-06*WS1' L=1.8e-7
MN_FA12_NAB_A nab12 a12 FA12_NAB_mid 0 NM W='2.3999999999999999e-06*WS2' L=1.8e-7
MN_FA12_NAB_B FA12_NAB_mid b12 0 0 NM W='2.3999999999999999e-06*WS2' L=1.8e-7
MP_FA12_NAB_A nab12 a12 vdd vdd PM W='4.7999999999999998e-06*WS2' L=1.8e-7
MP_FA12_NAB_B nab12 b12 vdd vdd PM W='4.7999999999999998e-06*WS2' L=1.8e-7
MN_FA12_NPC_A npc12 p12 FA12_NPC_mid 0 NM W='2.3999999999999999e-06*WS2' L=1.8e-7
MN_FA12_NPC_B FA12_NPC_mid c12 0 0 NM W='2.3999999999999999e-06*WS2' L=1.8e-7
MP_FA12_NPC_A npc12 p12 vdd vdd PM W='4.7999999999999998e-06*WS2' L=1.8e-7
MP_FA12_NPC_B npc12 c12 vdd vdd PM W='4.7999999999999998e-06*WS2' L=1.8e-7
MN_FA12_COUT_A c13 nab12 FA12_COUT_mid 0 NM W='7.9999999999999996e-06*WS3' L=1.8e-7
MN_FA12_COUT_B FA12_COUT_mid npc12 0 0 NM W='7.9999999999999996e-06*WS3' L=1.8e-7
MP_FA12_COUT_A c13 nab12 vdd vdd PM W='1.5999999999999999e-05*WS3' L=1.8e-7
MP_FA12_COUT_B c13 npc12 vdd vdd PM W='1.5999999999999999e-05*WS3' L=1.8e-7
MN_FA13_X0_IA FA13_X0_ab a13 0 0 NM W='1.1999999999999999e-06*WS0' L=1.8e-7
MP_FA13_X0_IA FA13_X0_ab a13 vdd vdd PM W='2.3999999999999999e-06*WS0' L=1.8e-7
MN_FA13_X0_IB FA13_X0_bb b13 0 0 NM W='1.1999999999999999e-06*WS0' L=1.8e-7
MP_FA13_X0_IB FA13_X0_bb b13 vdd vdd PM W='2.3999999999999999e-06*WS0' L=1.8e-7
MN_FA13_X0_00A p13 FA13_X0_ab FA13_X0_n00 0 NM W='1.7999999999999999e-06*WS1' L=1.8e-7
MN_FA13_X0_00B FA13_X0_n00 FA13_X0_bb 0 0 NM W='1.7999999999999999e-06*WS1' L=1.8e-7
MN_FA13_X0_11A p13 a13 FA13_X0_n11 0 NM W='1.7999999999999999e-06*WS1' L=1.8e-7
MN_FA13_X0_11B FA13_X0_n11 b13 0 0 NM W='1.7999999999999999e-06*WS1' L=1.8e-7
MP_FA13_X0_01A p13 a13 FA13_X0_p01 vdd PM W='3.5999999999999998e-06*WS1' L=1.8e-7
MP_FA13_X0_01B FA13_X0_p01 FA13_X0_bb vdd vdd PM W='3.5999999999999998e-06*WS1' L=1.8e-7
MP_FA13_X0_10A p13 FA13_X0_ab FA13_X0_p10 vdd PM W='3.5999999999999998e-06*WS1' L=1.8e-7
MP_FA13_X0_10B FA13_X0_p10 b13 vdd vdd PM W='3.5999999999999998e-06*WS1' L=1.8e-7
MN_FA13_X1_IA FA13_X1_ab p13 0 0 NM W='1.1999999999999999e-06*WS0' L=1.8e-7
MP_FA13_X1_IA FA13_X1_ab p13 vdd vdd PM W='2.3999999999999999e-06*WS0' L=1.8e-7
MN_FA13_X1_IB FA13_X1_bb c13 0 0 NM W='1.1999999999999999e-06*WS0' L=1.8e-7
MP_FA13_X1_IB FA13_X1_bb c13 vdd vdd PM W='2.3999999999999999e-06*WS0' L=1.8e-7
MN_FA13_X1_00A sum13 FA13_X1_ab FA13_X1_n00 0 NM W='1.7999999999999999e-06*WS1' L=1.8e-7
MN_FA13_X1_00B FA13_X1_n00 FA13_X1_bb 0 0 NM W='1.7999999999999999e-06*WS1' L=1.8e-7
MN_FA13_X1_11A sum13 p13 FA13_X1_n11 0 NM W='1.7999999999999999e-06*WS1' L=1.8e-7
MN_FA13_X1_11B FA13_X1_n11 c13 0 0 NM W='1.7999999999999999e-06*WS1' L=1.8e-7
MP_FA13_X1_01A sum13 p13 FA13_X1_p01 vdd PM W='3.5999999999999998e-06*WS1' L=1.8e-7
MP_FA13_X1_01B FA13_X1_p01 FA13_X1_bb vdd vdd PM W='3.5999999999999998e-06*WS1' L=1.8e-7
MP_FA13_X1_10A sum13 FA13_X1_ab FA13_X1_p10 vdd PM W='3.5999999999999998e-06*WS1' L=1.8e-7
MP_FA13_X1_10B FA13_X1_p10 c13 vdd vdd PM W='3.5999999999999998e-06*WS1' L=1.8e-7
MN_FA13_NAB_A nab13 a13 FA13_NAB_mid 0 NM W='2.3999999999999999e-06*WS2' L=1.8e-7
MN_FA13_NAB_B FA13_NAB_mid b13 0 0 NM W='2.3999999999999999e-06*WS2' L=1.8e-7
MP_FA13_NAB_A nab13 a13 vdd vdd PM W='4.7999999999999998e-06*WS2' L=1.8e-7
MP_FA13_NAB_B nab13 b13 vdd vdd PM W='4.7999999999999998e-06*WS2' L=1.8e-7
MN_FA13_NPC_A npc13 p13 FA13_NPC_mid 0 NM W='2.3999999999999999e-06*WS2' L=1.8e-7
MN_FA13_NPC_B FA13_NPC_mid c13 0 0 NM W='2.3999999999999999e-06*WS2' L=1.8e-7
MP_FA13_NPC_A npc13 p13 vdd vdd PM W='4.7999999999999998e-06*WS2' L=1.8e-7
MP_FA13_NPC_B npc13 c13 vdd vdd PM W='4.7999999999999998e-06*WS2' L=1.8e-7
MN_FA13_COUT_A c14 nab13 FA13_COUT_mid 0 NM W='7.9999999999999996e-06*WS3' L=1.8e-7
MN_FA13_COUT_B FA13_COUT_mid npc13 0 0 NM W='7.9999999999999996e-06*WS3' L=1.8e-7
MP_FA13_COUT_A c14 nab13 vdd vdd PM W='1.5999999999999999e-05*WS3' L=1.8e-7
MP_FA13_COUT_B c14 npc13 vdd vdd PM W='1.5999999999999999e-05*WS3' L=1.8e-7
MN_FA14_X0_IA FA14_X0_ab a14 0 0 NM W='1.1999999999999999e-06*WS0' L=1.8e-7
MP_FA14_X0_IA FA14_X0_ab a14 vdd vdd PM W='2.3999999999999999e-06*WS0' L=1.8e-7
MN_FA14_X0_IB FA14_X0_bb b14 0 0 NM W='1.1999999999999999e-06*WS0' L=1.8e-7
MP_FA14_X0_IB FA14_X0_bb b14 vdd vdd PM W='2.3999999999999999e-06*WS0' L=1.8e-7
MN_FA14_X0_00A p14 FA14_X0_ab FA14_X0_n00 0 NM W='1.7999999999999999e-06*WS1' L=1.8e-7
MN_FA14_X0_00B FA14_X0_n00 FA14_X0_bb 0 0 NM W='1.7999999999999999e-06*WS1' L=1.8e-7
MN_FA14_X0_11A p14 a14 FA14_X0_n11 0 NM W='1.7999999999999999e-06*WS1' L=1.8e-7
MN_FA14_X0_11B FA14_X0_n11 b14 0 0 NM W='1.7999999999999999e-06*WS1' L=1.8e-7
MP_FA14_X0_01A p14 a14 FA14_X0_p01 vdd PM W='3.5999999999999998e-06*WS1' L=1.8e-7
MP_FA14_X0_01B FA14_X0_p01 FA14_X0_bb vdd vdd PM W='3.5999999999999998e-06*WS1' L=1.8e-7
MP_FA14_X0_10A p14 FA14_X0_ab FA14_X0_p10 vdd PM W='3.5999999999999998e-06*WS1' L=1.8e-7
MP_FA14_X0_10B FA14_X0_p10 b14 vdd vdd PM W='3.5999999999999998e-06*WS1' L=1.8e-7
MN_FA14_X1_IA FA14_X1_ab p14 0 0 NM W='1.1999999999999999e-06*WS0' L=1.8e-7
MP_FA14_X1_IA FA14_X1_ab p14 vdd vdd PM W='2.3999999999999999e-06*WS0' L=1.8e-7
MN_FA14_X1_IB FA14_X1_bb c14 0 0 NM W='1.1999999999999999e-06*WS0' L=1.8e-7
MP_FA14_X1_IB FA14_X1_bb c14 vdd vdd PM W='2.3999999999999999e-06*WS0' L=1.8e-7
MN_FA14_X1_00A sum14 FA14_X1_ab FA14_X1_n00 0 NM W='1.7999999999999999e-06*WS1' L=1.8e-7
MN_FA14_X1_00B FA14_X1_n00 FA14_X1_bb 0 0 NM W='1.7999999999999999e-06*WS1' L=1.8e-7
MN_FA14_X1_11A sum14 p14 FA14_X1_n11 0 NM W='1.7999999999999999e-06*WS1' L=1.8e-7
MN_FA14_X1_11B FA14_X1_n11 c14 0 0 NM W='1.7999999999999999e-06*WS1' L=1.8e-7
MP_FA14_X1_01A sum14 p14 FA14_X1_p01 vdd PM W='3.5999999999999998e-06*WS1' L=1.8e-7
MP_FA14_X1_01B FA14_X1_p01 FA14_X1_bb vdd vdd PM W='3.5999999999999998e-06*WS1' L=1.8e-7
MP_FA14_X1_10A sum14 FA14_X1_ab FA14_X1_p10 vdd PM W='3.5999999999999998e-06*WS1' L=1.8e-7
MP_FA14_X1_10B FA14_X1_p10 c14 vdd vdd PM W='3.5999999999999998e-06*WS1' L=1.8e-7
MN_FA14_NAB_A nab14 a14 FA14_NAB_mid 0 NM W='2.3999999999999999e-06*WS2' L=1.8e-7
MN_FA14_NAB_B FA14_NAB_mid b14 0 0 NM W='2.3999999999999999e-06*WS2' L=1.8e-7
MP_FA14_NAB_A nab14 a14 vdd vdd PM W='4.7999999999999998e-06*WS2' L=1.8e-7
MP_FA14_NAB_B nab14 b14 vdd vdd PM W='4.7999999999999998e-06*WS2' L=1.8e-7
MN_FA14_NPC_A npc14 p14 FA14_NPC_mid 0 NM W='2.3999999999999999e-06*WS2' L=1.8e-7
MN_FA14_NPC_B FA14_NPC_mid c14 0 0 NM W='2.3999999999999999e-06*WS2' L=1.8e-7
MP_FA14_NPC_A npc14 p14 vdd vdd PM W='4.7999999999999998e-06*WS2' L=1.8e-7
MP_FA14_NPC_B npc14 c14 vdd vdd PM W='4.7999999999999998e-06*WS2' L=1.8e-7
MN_FA14_COUT_A c15 nab14 FA14_COUT_mid 0 NM W='7.9999999999999996e-06*WS3' L=1.8e-7
MN_FA14_COUT_B FA14_COUT_mid npc14 0 0 NM W='7.9999999999999996e-06*WS3' L=1.8e-7
MP_FA14_COUT_A c15 nab14 vdd vdd PM W='1.5999999999999999e-05*WS3' L=1.8e-7
MP_FA14_COUT_B c15 npc14 vdd vdd PM W='1.5999999999999999e-05*WS3' L=1.8e-7
MN_FA15_X0_IA FA15_X0_ab a15 0 0 NM W='1.1999999999999999e-06*WS0' L=1.8e-7
MP_FA15_X0_IA FA15_X0_ab a15 vdd vdd PM W='2.3999999999999999e-06*WS0' L=1.8e-7
MN_FA15_X0_IB FA15_X0_bb b15 0 0 NM W='1.1999999999999999e-06*WS0' L=1.8e-7
MP_FA15_X0_IB FA15_X0_bb b15 vdd vdd PM W='2.3999999999999999e-06*WS0' L=1.8e-7
MN_FA15_X0_00A p15 FA15_X0_ab FA15_X0_n00 0 NM W='1.7999999999999999e-06*WS1' L=1.8e-7
MN_FA15_X0_00B FA15_X0_n00 FA15_X0_bb 0 0 NM W='1.7999999999999999e-06*WS1' L=1.8e-7
MN_FA15_X0_11A p15 a15 FA15_X0_n11 0 NM W='1.7999999999999999e-06*WS1' L=1.8e-7
MN_FA15_X0_11B FA15_X0_n11 b15 0 0 NM W='1.7999999999999999e-06*WS1' L=1.8e-7
MP_FA15_X0_01A p15 a15 FA15_X0_p01 vdd PM W='3.5999999999999998e-06*WS1' L=1.8e-7
MP_FA15_X0_01B FA15_X0_p01 FA15_X0_bb vdd vdd PM W='3.5999999999999998e-06*WS1' L=1.8e-7
MP_FA15_X0_10A p15 FA15_X0_ab FA15_X0_p10 vdd PM W='3.5999999999999998e-06*WS1' L=1.8e-7
MP_FA15_X0_10B FA15_X0_p10 b15 vdd vdd PM W='3.5999999999999998e-06*WS1' L=1.8e-7
MN_FA15_X1_IA FA15_X1_ab p15 0 0 NM W='1.1999999999999999e-06*WS0' L=1.8e-7
MP_FA15_X1_IA FA15_X1_ab p15 vdd vdd PM W='2.3999999999999999e-06*WS0' L=1.8e-7
MN_FA15_X1_IB FA15_X1_bb c15 0 0 NM W='1.1999999999999999e-06*WS0' L=1.8e-7
MP_FA15_X1_IB FA15_X1_bb c15 vdd vdd PM W='2.3999999999999999e-06*WS0' L=1.8e-7
MN_FA15_X1_00A sum15 FA15_X1_ab FA15_X1_n00 0 NM W='1.7999999999999999e-06*WS1' L=1.8e-7
MN_FA15_X1_00B FA15_X1_n00 FA15_X1_bb 0 0 NM W='1.7999999999999999e-06*WS1' L=1.8e-7
MN_FA15_X1_11A sum15 p15 FA15_X1_n11 0 NM W='1.7999999999999999e-06*WS1' L=1.8e-7
MN_FA15_X1_11B FA15_X1_n11 c15 0 0 NM W='1.7999999999999999e-06*WS1' L=1.8e-7
MP_FA15_X1_01A sum15 p15 FA15_X1_p01 vdd PM W='3.5999999999999998e-06*WS1' L=1.8e-7
MP_FA15_X1_01B FA15_X1_p01 FA15_X1_bb vdd vdd PM W='3.5999999999999998e-06*WS1' L=1.8e-7
MP_FA15_X1_10A sum15 FA15_X1_ab FA15_X1_p10 vdd PM W='3.5999999999999998e-06*WS1' L=1.8e-7
MP_FA15_X1_10B FA15_X1_p10 c15 vdd vdd PM W='3.5999999999999998e-06*WS1' L=1.8e-7
MN_FA15_NAB_A nab15 a15 FA15_NAB_mid 0 NM W='2.3999999999999999e-06*WS2' L=1.8e-7
MN_FA15_NAB_B FA15_NAB_mid b15 0 0 NM W='2.3999999999999999e-06*WS2' L=1.8e-7
MP_FA15_NAB_A nab15 a15 vdd vdd PM W='4.7999999999999998e-06*WS2' L=1.8e-7
MP_FA15_NAB_B nab15 b15 vdd vdd PM W='4.7999999999999998e-06*WS2' L=1.8e-7
MN_FA15_NPC_A npc15 p15 FA15_NPC_mid 0 NM W='2.3999999999999999e-06*WS2' L=1.8e-7
MN_FA15_NPC_B FA15_NPC_mid c15 0 0 NM W='2.3999999999999999e-06*WS2' L=1.8e-7
MP_FA15_NPC_A npc15 p15 vdd vdd PM W='4.7999999999999998e-06*WS2' L=1.8e-7
MP_FA15_NPC_B npc15 c15 vdd vdd PM W='4.7999999999999998e-06*WS2' L=1.8e-7
MN_FA15_COUT_A c16 nab15 FA15_COUT_mid 0 NM W='7.9999999999999996e-06*WS3' L=1.8e-7
MN_FA15_COUT_B FA15_COUT_mid npc15 0 0 NM W='7.9999999999999996e-06*WS3' L=1.8e-7
MP_FA15_COUT_A c16 nab15 vdd vdd PM W='1.5999999999999999e-05*WS3' L=1.8e-7
MP_FA15_COUT_B c16 npc15 vdd vdd PM W='1.5999999999999999e-05*WS3' L=1.8e-7
MN_COUT_BUF0 cout_b c16 0 0 NM W='7.9999999999999996e-06*WS3' L=1.8e-7
MP_COUT_BUF0 cout_b c16 vdd vdd PM W='1.5999999999999999e-05*WS3' L=1.8e-7
MN_COUT_BUF1 cout cout_b 0 0 NM W='7.9999999999999996e-06*WS3' L=1.8e-7
MP_COUT_BUF1 cout cout_b vdd vdd PM W='1.5999999999999999e-05*WS3' L=1.8e-7
CLOAD_sum00 sum00 0 2e-14
CLOAD_sum05 sum05 0 2e-14
CLOAD_sum10 sum10 0 2e-14
CLOAD_sum15 sum15 0 2e-14
CLOAD_c04 c04 0 2e-14
CLOAD_c08 c08 0 2e-14
CLOAD_c12 c12 0 2e-14
CLOAD_cout cout 0 2e-14
.dc VDD 0.8 1.8 0.05
.print dc v(sum00) v(sum05) v(sum10) v(sum15) v(c04) v(c08) v(c12) v(cout) i(VDD)
.alter p000001
.param VTHN=0.4416960313164332 VTHP=-0.4532675514368949 U0N=0.054724914205196845 U0P=0.020404897023237323 RDSWN=97.576109085495176 RDSWP=116.85102835365008 VSATN=75478.12811154114 VSATP=77062.760408557355 ETA0N=0.080435244689600047 ETA0P=0.076607981130987865 WS0=1.0178994352543229 WS1=0.98263236961936784 WS2=1.0415687192824925 WS3=1.0547795127571304
.alter p000002
.param VTHN=0.46491769949940609 VTHP=-0.45865466766240509 U0N=0.046727852190048734 U0P=0.018425943840254033 RDSWN=104.78000927547589 RDSWP=113.35504216102532 VSATN=78677.730953723207 VSATP=74876.706575867516 ETA0N=0.080084308024550105 ETA0P=0.077970201016476295 WS0=1.088283844172778 WS1=0.9342640679167451 WS2=1.0713255540580897 WS3=0.99484078422620237
.alter p000003
.param VTHN=0.45667128430832954 VTHP=-0.47250069269426731 U0N=0.047759465422216825 U0P=0.01891063529661248 RDSWN=108.53063414393735 RDSWP=108.96779365498017 VSATN=86118.979285999318 VSATP=76162.810464638082 ETA0N=0.075014434473199387 ETA0P=0.078502203644315385 WS0=1.0371247722231445 WS1=1.0550425731897928 WS2=0.92532304738848803 WS3=1.0866314150251111
.alter p000004
.param VTHN=0.42887517271908149 VTHP=-0.44641858129778245 U0N=0.052076722159991443 U0P=0.018133164379206663 RDSWN=97.825918937038011 RDSWP=114.04744445207079 VSATN=81628.125581516491 VSATP=75439.647769938412 ETA0N=0.073789423157502532 ETA0P=0.087891071905445164 WS0=0.90157231341960808 WS1=0.90084149641583744 WS2=1.0885479940738818 WS3=1.0643917650893009
.alter p000005
.param VTHN=0.42062976228570609 VTHP=-0.47532511469164346 U0N=0.045986391342465655 U0P=0.0207865039080629 RDSWN=91.57719414651001 RDSWP=124.15476689493943 VSATN=73421.275473975227 VSATP=86011.616771304543 ETA0N=0.082291906621727029 ETA0P=0.075283092756474268 WS0=1.0738836304791741 WS1=1.0747705751756211 WS2=0.92023215427767324 WS3=1.0906466519882607
.alter p000006
.param VTHN=0.42138780776688017 VTHP=-0.42322228605583578 U0N=0.047359720325786003 U0P=0.02076627523936582 RDSWN=94.635862262155541 RDSWP=112.08739725960683 VSATN=85948.727223747919 VSATP=86077.072288854921 ETA0N=0.085976119657146022 ETA0P=0.086354164174372069 WS0=0.93949918453018033 WS1=1.0184266608053729 WS2=1.0827542532567387 WS3=0.92158507920998622
.alter p000007
.param VTHN=0.46812422049213187 VTHP=-0.43730854524382734 U0N=0.053452486719753722 U0P=0.01818899910651512 RDSWN=107.54347614911727 RDSWP=122.48052288265656 VSATN=75740.432771009859 VSATP=87484.796977788574 ETA0N=0.074216356099342698 ETA0P=0.081576772900871897 WS0=0.93697611759489019 WS1=0.99170689585539273 WS2=1.0460596227919086 WS3=1.0478662646431864
.alter p000008
.param VTHN=0.4736271953963182 VTHP=-0.42787136856370245 U0N=0.049086589780280382 U0P=0.01880149311864698 RDSWN=100.57080509450454 RDSWP=128.01324363712268 VSATN=87896.275986940629 VSATP=86794.766491619899 ETA0N=0.08277948353215947 ETA0P=0.074727202431229933 WS0=1.0558060639899538 WS1=0.93721643908579577 WS2=1.0958492461173266 WS3=0.93104808354788071
.alter p000009
.param VTHN=0.46113088651321543 VTHP=-0.45951877739644703 U0N=0.045507117306345879 U0P=0.020092225027548007 RDSWN=94.306886023369273 RDSWP=120.88687407697961 VSATN=76243.390353242459 VSATP=75871.08660228677 ETA0N=0.077750377671547605 ETA0P=0.081609608179626911 WS0=0.95857051896890766 WS1=0.90002993035741052 WS2=0.92645191792125892 WS3=1.0399229736609898
.alter p000010
.param VTHN=0.45404444337550692 VTHP=-0.44526248748522901 U0N=0.047378691626468468 U0P=0.018332848775408413 RDSWN=105.74139629776036 RDSWP=121.14472570783518 VSATN=79112.571770226961 VSATP=83688.404214029433 ETA0N=0.075485982983022268 ETA0P=0.077061072350568374 WS0=1.066898081309466 WS1=1.0980220808569094 WS2=1.0324536632477501 WS3=0.9884622483738883
.alter p000011
.param VTHN=0.47323242409370297 VTHP=-0.43391134824729866 U0N=0.053011773794342021 U0P=0.019130334161729566 RDSWN=105.83447483771815 RDSWP=116.28629336043042 VSATN=87760.933355770903 VSATP=72638.982889843814 ETA0N=0.081096953358928414 ETA0P=0.079421337906943515 WS0=0.98024539086601803 WS1=0.9505882583911015 WS2=0.92869247836939661 WS3=1.0253284893467645
.alter p000012
.param VTHN=0.4457378098221248 VTHP=-0.43591502358579559 U0N=0.046081427408600217 U0P=0.019018886208324128 RDSWN=100.75969591064674 RDSWP=128.96916030165517 VSATN=82272.583008271075 VSATP=84638.780188128192 ETA0N=0.085799870204509257 ETA0P=0.073691760059541089 WS0=1.0060757674169805 WS1=0.99009381928389717 WS2=0.96957565372771537 WS3=0.94463840119088727
.alter p000013
.param VTHN=0.45036997572507498 VTHP=-0.4340934330331116 U0N=0.053082025219420834 U0P=0.019657839028668422 RDSWN=102.06972799660751 RDSWP=109.35921718691797 VSATN=72763.615192496713 VSATP=85827.969343109493 ETA0N=0.085059623457668293 ETA0P=0.074821141390591234 WS0=0.9824837531255064 WS1=0.96624779296170427 WS2=1.0981016814617566 WS3=0.98283645456232938
.alter p000014
.param VTHN=0.42589150210194737 VTHP=-0.42981690055205241 U0N=0.048164641217214137 U0P=0.019412399622300285 RDSWN=99.436018622185287 RDSWP=123.64500754437195 VSATN=73588.834523961501 VSATP=74235.51483267505 ETA0N=0.086360138397820571 ETA0P=0.086477637980987454 WS0=1.0582909393322271 WS1=1.0796556259643169 WS2=0.97456747233434349 WS3=1.0291435933117381
.alter p000015
.param VTHN=0.42792153684236295 VTHP=-0.47714511023425005 U0N=0.05421779283834248 U0P=0.020563508130432343 RDSWN=98.043428282352693 RDSWP=113.19830233631106 VSATN=80985.015256673767 VSATP=79777.186760795579 ETA0N=0.078487142864782769 ETA0P=0.076857098800277052 WS0=0.96399362279344558 WS1=0.98157719369537166 WS2=1.0154306890387488 WS3=1.0216187323107231
.alter p000016
.param VTHN=0.47674935245046757 VTHP=-0.44581627164719484 U0N=0.046233018664728794 U0P=0.020195342769425861 RDSWN=109.31106631417734 RDSWP=109.00832995046163 VSATN=87776.501810399874 VSATP=86663.120256277107 ETA0N=0.079188562609036561 ETA0P=0.075250016709981771 WS0=1.0948795373682341 WS1=0.99300590520476761 WS2=1.055170189845112 WS3=0.92163185957686344
.alter p000017
.param VTHN=0.44287269005987751 VTHP=-0.4352500826314506 U0N=0.047225057657365913 U0P=0.019912416127296551 RDSWN=100.63185444199689 RDSWP=127.30887342008364 VSATN=83511.479932428163 VSATP=84911.693166896846 ETA0N=0.073439848765491811 ETA0P=0.086202000222877037 WS0=1.080573450728747 WS1=1.0541935177168966 WS2=1.086358713999735 WS3=0.92504829077261341
.alter p000018
.param VTHN=0.46604716207932573 VTHP=-0.47550367160792506 U0N=0.045185374062198601 U0P=0.021108287998445632 RDSWN=96.205353602716386 RDSWP=125.61571421186781 VSATN=87952.394238217239 VSATP=84254.51210770497 ETA0N=0.084544398602124038 ETA0P=0.085858793349139567 WS0=1.0964529786623103 WS1=1.032720695443232 WS2=1.0612142051958302 WS3=0.90314198747664542
.alter p000019
.param VTHN=0.47137355387929986 VTHP=-0.45640444557404863 U0N=0.045116013756376139 U0P=0.018075756325022993 RDSWN=90.183670874467026 RDSWP=129.68397319477307 VSATN=85893.354737531408 VSATP=72815.64950966055 ETA0N=0.087294283187993704 ETA0P=0.080982601471054752 WS0=1.0747660793456244 WS1=0.91878363108923977 WS2=1.0123204116125364 WS3=0.94050457079420668
.alter p000020
.param VTHN=0.43311604125471032 VTHP=-0.47315509651398119 U0N=0.054061359524004218 U0P=0.020083384712130663 RDSWN=106.08302853246711 RDSWP=114.21853675167812 VSATN=75219.776303912004 VSATP=76653.837331110335 ETA0N=0.072322389970367246 ETA0P=0.076230974102417068 WS0=1.0514721438728025 WS1=0.92719657647082343 WS2=1.085869201012754 WS3=0.96401929352660687
.alter p000021
.param VTHN=0.44021866282092953 VTHP=-0.47482897166145061 U0N=0.048292798380353018 U0P=0.020395006090049284 RDSWN=99.828885694364118 RDSWP=125.5678243174227 VSATN=81903.00999981942 VSATP=76278.891424847738 ETA0N=0.085710326198217293 ETA0P=0.073820357667436165 WS0=0.97002283308540305 WS1=0.9731366507195931 WS2=0.97214393910002261 WS3=0.9349773137206645
.alter p000022
.param VTHN=0.42152232425274616 VTHP=-0.47530837791992298 U0N=0.046448617222289774 U0P=0.020965040861766353 RDSWN=90.138097737193505 RDSWP=116.88919706658662 VSATN=74781.488135226886 VSATP=81041.320639165322 ETA0N=0.078379454496909862 ETA0P=0.078832430967311268 WS0=1.0590704049775483 WS1=1.0229222201027284 WS2=0.96308057283001058 WS3=1.0582823737011522
.alter p000023
.param VTHN=0.43615073866887327 VTHP=-0.42484588756280217 U0N=0.046807746755207637 U0P=0.018411680687166296 RDSWN=101.75102834374303 RDSWP=119.40069411214294 VSATN=84953.304986411138 VSATP=86271.005467163879 ETA0N=0.077721012603189643 ETA0P=0.075313543565217189 WS0=0.91555805101699095 WS1=0.90268618613158125 WS2=0.90377693121061842 WS3=1.0853196881546683
.alter p000024
.param VTHN=0.44811353170729173 VTHP=-0.45973419983862435 U0N=0.051222934873950368 U0P=0.021735422988188133 RDSWN=95.560481923687647 RDSWP=119.78772822279343 VSATN=72294.607105678035 VSATP=80888.471157468681 ETA0N=0.086036459082838898 ETA0P=0.084359178431292814 WS0=1.0810919897082478 WS1=1.058282046453378 WS2=1.0733395678090241 WS3=1.0960030475448317
.alter p000025
.param VTHN=0.46347000109739844 VTHP=-0.47167013958761739 U0N=0.049493375689986477 U0P=0.021479623573732856 RDSWN=96.395186292875891 RDSWP=124.94534427570062 VSATN=87590.251807589666 VSATP=79884.806273938666 ETA0N=0.085930980028019674 ETA0P=0.087907460721221867 WS0=0.93221648033921811 WS1=0.94352440909611923 WS2=1.0175544411869304 WS3=0.93312056439399493
.alter p000026
.param VTHN=0.42635239407932257 VTHP=-0.47989281563450942 U0N=0.047781291029107151 U0P=0.019247115849112127 RDSWN=90.510378040265394 RDSWP=115.1871628388667 VSATN=81279.557420326935 VSATP=72657.435695942782 ETA0N=0.087951333408454041 ETA0P=0.072297498279842762 WS0=1.0324966749193374 WS1=1.0674986238501356 WS2=0.97734788735536315 WS3=1.0374011557634957
.alter p000027
.param VTHN=0.44995152318846893 VTHP=-0.44670856146444371 U0N=0.051931172188713549 U0P=0.018416867717233245 RDSWN=104.2274247060127 RDSWP=129.89528921418753 VSATN=82548.108706397063 VSATP=83306.696522737941 ETA0N=0.083228667010698199 ETA0P=0.072023166687584836 WS0=0.91332643307738171 WS1=0.98913681852598612 WS2=1.0740678271606534 WS3=1.0473282034822495
.alter p000028
.param VTHN=0.4422583098660669 VTHP=-0.44421038991070694 U0N=0.05092425119371314 U0P=0.018343863216181731 RDSWN=104.5362162156559 RDSWP=110.84639744626251 VSATN=85187.037228827336 VSATP=80350.567437264646 ETA0N=0.077911555662780047 ETA0P=0.086539115326642671 WS0=0.92353367591394087 WS1=0.984333940213584 WS2=1.0130094396220228 WS3=1.0346900055980421
.alter p000029
.param VTHN=0.44555345860267698 VTHP=-0.44261648723499125 U0N=0.050559644696496195 U0P=0.018640458501275634 RDSWN=106.58006660200634 RDSWP=112.32380062661163 VSATN=74586.583640263038 VSATP=82128.673460117992 ETA0N=0.08667743240234338 ETA0P=0.074292402385943437 WS0=0.97323922865900203 WS1=1.0651045609752303 WS2=0.93876836828057864 WS3=1.0787970813581143
.alter p000030
.param VTHN=0.42680667809947664 VTHP=-0.44913844393550084 U0N=0.051869826518594786 U0P=0.021824661941313654 RDSWN=95.30079015219134 RDSWP=111.8509309257565 VSATN=75448.482501931489 VSATP=82195.847583136128 ETA0N=0.084195711686672989 ETA0P=0.080818362735527546 WS0=1.0816562513599099 WS1=1.0707627357752338 WS2=0.93645953459520237 WS3=0.98527471638167752
.alter p000031
.param VTHN=0.44758651059088733 VTHP=-0.45746761883613146 U0N=0.052597752318542752 U0P=0.01968939023636361 RDSWN=106.42398503475491 RDSWP=128.42776420494448 VSATN=83801.56157434333 VSATP=80863.193145113459 ETA0N=0.077643450485670784 ETA0P=0.084431566803319147 WS0=0.97268405770387478 WS1=0.97339317643257695 WS2=0.99147288541703593 WS3=0.940186764712167
.alter p000032
.param VTHN=0.43048552338114809 VTHP=-0.44917414658714955 U0N=0.049398810383216155 U0P=0.019681651852989 RDSWN=95.955872948152717 RDSWP=118.93335608846371 VSATN=81514.058281224148 VSATP=79243.276362645163 ETA0N=0.076135564590116056 ETA0P=0.074103198172691898 WS0=0.93753743902729358 WS1=0.90045936127411041 WS2=0.9042648717469185 WS3=0.95430923169218529
.alter p000033
.param VTHN=0.43547092054522285 VTHP=-0.4779551408880014 U0N=0.047885154379800655 U0P=0.020685695757301226 RDSWN=109.46266832613426 RDSWP=113.81377056020602 VSATN=73870.06881566385 VSATP=82521.31016410864 ETA0N=0.073826023309681216 ETA0P=0.072995499437995409 WS0=0.95947070630656339 WS1=1.0457600937107618 WS2=1.0026007577091345 WS3=1.032502377990089
.alter p000034
.param VTHN=0.4750069118989193 VTHP=-0.45446375218854573 U0N=0.053992213048173837 U0P=0.019478088205638473 RDSWN=107.64258071721981 RDSWP=130.53796108700152 VSATN=87424.721512912089 VSATP=81161.02439038147 ETA0N=0.083699182575617301 ETA0P=0.083172811016394579 WS0=1.0901091756691998 WS1=0.9094865627199481 WS2=0.949665096879304 WS3=1.0746162940705291
.alter p000035
.param VTHN=0.42002857946247868 VTHP=-0.4794789200993731 U0N=0.047720550572638194 U0P=0.020666920916797296 RDSWN=105.70654165126143 RDSWP=122.69506171305578 VSATN=84797.435157815547 VSATP=76804.609628656501 ETA0N=0.072681913443992566 ETA0P=0.076904680161051148 WS0=0.96637383766074592 WS1=1.0936261048364564 WS2=0.97963402345185935 WS3=1.0355523577848089
.alter p000036
.param VTHN=0.44941504008520444 VTHP=-0.44624441591507163 U0N=0.053684313112904614 U0P=0.019873354421621598 RDSWN=109.09200030598491 RDSWP=114.94906565121849 VSATN=87010.765804406357 VSATP=86977.928589783056 ETA0N=0.072406256073965017 ETA0P=0.082682429648919795 WS0=0.92243668953790825 WS1=0.98662150403053395 WS2=0.95467021186856349 WS3=0.90516027205108962
.alter p000037
.param VTHN=0.4287053473595443 VTHP=-0.45623222688532261 U0N=0.050782948822173407 U0P=0.018865391318337574 RDSWN=106.26867668728664 RDSWP=119.05687682870453 VSATN=77771.426841183042 VSATP=85657.001907128317 ETA0N=0.076296600482907873 ETA0P=0.087338531638395042 WS0=0.96451998508297054 WS1=1.0418039639230114 WS2=0.93405471114098249 WS3=0.99081727783982265
.alter p000038
.param VTHN=0.42458274308321353 VTHP=-0.47806377439067577 U0N=0.051969044693871973 U0P=0.019262255708281474 RDSWN=104.18988483679888 RDSWP=113.2889853306604 VSATN=75854.525088645882 VSATP=77452.056460172389 ETA0N=0.072904227261383944 ETA0P=0.080833532221615392 WS0=1.0100307982564265 WS1=1.0794540382318014 WS2=0.97191753715423601 WS3=0.90669682718237377
.alter p000039
.param VTHN=0.45717023761875675 VTHP=-0.42944388733541572 U0N=0.050941033190008964 U0P=0.021024022536584478 RDSWN=97.84216610760528 RDSWP=109.92650186672385 VSATN=83909.961067306358 VSATP=84697.572208260506 ETA0N=0.087700623715637943 ETA0P=0.085288018444640401 WS0=1.0412226683457102 WS1=1.0393012297346951 WS2=1.0249780124903607 WS3=0.91745826771112737
.alter p000040
.param VTHN=0.46778139479323116 VTHP=-0.43598382154775595 U0N=0.053140011941643341 U0P=0.018548038888764756 RDSWN=109.37466476243233 RDSWP=118.07077845905815 VSATN=84324.624879808471 VSATP=81495.178213255218 ETA0N=0.078906689591196802 ETA0P=0.072877226973487558 WS0=1.0793979829922353 WS1=0.9399813134488183 WS2=1.0731697143228258 WS3=0.91956741754512905
.alter p000041
.param VTHN=0.47100534002471717 VTHP=-0.46200227947617656 U0N=0.045158988858499095 U0P=0.020030983874784438 RDSWN=101.81989911574331 RDSWP=129.57539528703131 VSATN=79609.333317704324 VSATP=73391.502997183954 ETA0N=0.077419018761324759 ETA0P=0.087324900990737947 WS0=1.0410708099910131 WS1=1.0245041584057519 WS2=1.0789593296323989 WS3=0.91661862032866914
.alter p000042
.param VTHN=0.42561960453719627 VTHP=-0.45064991379263297 U0N=0.050201049879777387 U0P=0.01810205584092929 RDSWN=97.600977846740051 RDSWP=110.75021786510801 VSATN=81678.734762206252 VSATP=75393.866319815672 ETA0N=0.078161520720021332 ETA0P=0.072415097204934692 WS0=1.0221607141475535 WS1=1.00001683979112 WS2=0.90728371569014388 WS3=0.9797329312456019
.alter p000043
.param VTHN=0.44532747810209117 VTHP=-0.42759172877968071 U0N=0.048031772286232226 U0P=0.021366349436951385 RDSWN=105.04569267953801 RDSWP=113.78949375346234 VSATN=76446.794228214625 VSATP=72875.858231383565 ETA0N=0.077145944838808433 ETA0P=0.077129732554176697 WS0=1.0498357623538193 WS1=0.93248513981746228 WS2=1.0892795182562733 WS3=1.0834808574238894
.alter p000044
.param VTHN=0.43058979548298804 VTHP=-0.45604953686275951 U0N=0.049513290253177578 U0P=0.019086037056737774 RDSWN=102.196818793909 RDSWP=114.30593553731023 VSATN=79430.234545168321 VSATP=81123.007784516129 ETA0N=0.074949993262998241 ETA0P=0.072850046001397412 WS0=0.92753009167949496 WS1=0.93790839516877411 WS2=1.0944061887196246 WS3=1.067865861867864
.alter p000045
.param VTHN=0.45347449468731343 VTHP=-0.44405365209971914 U0N=0.046325897469542639 U0P=0.020511657400195914 RDSWN=97.385957303320083 RDSWP=123.03546335859474 VSATN=73998.761404523 VSATP=83341.732770111965 ETA0N=0.073505186685461021 ETA0P=0.083030500875796956 WS0=1.0329253595250902 WS1=0.93682889901940902 WS2=1.0245484709204107 WS3=0.95584000995769391
.alter p000046
.param VTHN=0.4563734013712033 VTHP=-0.45836057254024848 U0N=0.049616656607798411 U0P=0.018586295227923644 RDSWN=106.38235400516439 RDSWP=108.72621259851023 VSATN=86820.963010539213 VSATP=81570.366272906453 ETA0N=0.087915790018983475 ETA0P=0.073524655099527936 WS0=0.93522403433596446 WS1=0.98573571500983825 WS2=0.94377548544454137 WS3=1.040180872670591
.alter p000047
.param VTHN=0.45560585135731285 VTHP=-0.45542288585423768 U0N=0.046405194005114253 U0P=0.020220628619400414 RDSWN=92.400738383780151 RDSWP=118.59436788796789 VSATN=84145.212761759627 VSATP=77820.421426597532 ETA0N=0.081996302339492608 ETA0P=0.078255431735585565 WS0=1.0643246055459181 WS1=0.94732895200260658 WS2=1.0752863583373411 WS3=0.95931442576254111
.alter p000048
.param VTHN=0.4517027298299045 VTHP=-0.42468934034669981 U0N=0.04613100620876056 U0P=0.01926702226937799 RDSWN=94.326812634922916 RDSWP=109.68279094963547 VSATN=78009.586160662555 VSATP=83487.857708905183 ETA0N=0.086369320485201198 ETA0P=0.075705644640004968 WS0=1.0997282464855502 WS1=0.93559586814103068 WS2=0.97811729241485978 WS3=1.077939244451217
.alter p000049
.param VTHN=0.42999917579907726 VTHP=-0.46871542292817364 U0N=0.046035428527725381 U0P=0.019543602024094827 RDSWN=93.761999762338931 RDSWP=113.86304929849372 VSATN=75985.889055620966 VSATP=82422.711456301928 ETA0N=0.083979556093815438 ETA0P=0.079057848078298243 WS0=1.0447677001657778 WS1=0.95695384795244898 WS2=0.90231261620065517 WS3=1.0928830344806484
.alter p000050
.param VTHN=0.46363813507284807 VTHP=-0.4732681575155035 U0N=0.053055771484750852 U0P=0.02146782308507094 RDSWN=93.037110311190901 RDSWP=119.24363684970596 VSATN=82996.772098513815 VSATP=73319.430498770729 ETA0N=0.076494586583277471 ETA0P=0.074597090995898424 WS0=1.0829653158641086 WS1=1.019090520420338 WS2=1.0689450563873257 WS3=0.98883061412290751
.alter p000051
.param VTHN=0.42568472605604846 VTHP=-0.47604283219673516 U0N=0.052008337307326326 U0P=0.021082834866528385 RDSWN=98.751006695936496 RDSWP=118.22446386115855 VSATN=82396.758081112872 VSATP=74825.576384593063 ETA0N=0.085503578879775943 ETA0P=0.076628546151294732 WS0=1.0516543753209358 WS1=1.0387647733078869 WS2=0.90184632378203744 WS3=1.0883083421514372
.alter p000052
.param VTHN=0.47427497348471997 VTHP=-0.43573056086105189 U0N=0.045662739415240641 U0P=0.018678861678279649 RDSWN=96.017122147510733 RDSWP=108.30753907866864 VSATN=78268.24681822554 VSATP=86885.781535006914 ETA0N=0.086326743644415532 ETA0P=0.08749646777773136 WS0=1.0836304974719386 WS1=1.0045718157807526 WS2=1.0387334672034698 WS3=1.0715197072101093
.alter p000053
.param VTHN=0.4387197610030163 VTHP=-0.45578819815331034 U0N=0.052681042849300135 U0P=0.021772477230276331 RDSWN=108.23624582480348 RDSWP=117.10186778618321 VSATN=86942.930308159368 VSATP=78559.364927800969 ETA0N=0.084996589461650784 ETA0P=0.072927899844541857 WS0=1.0865307945159748 WS1=1.026376990598862 WS2=0.9213358524868217 WS3=0.90744184792464133
.alter p000054
.param VTHN=0.42096600903295744 VTHP=-0.43536511836647501 U0N=0.052402246673039124 U0P=0.018262751503662099 RDSWN=96.961901390993461 RDSWP=108.86211837156694 VSATN=86255.632779014646 VSATP=79732.410899135342 ETA0N=0.084950423211661935 ETA0P=0.08579808180406312 WS0=0.99111059950781399 WS1=1.0758987206992301 WS2=0.94843149651447067 WS3=0.97908055562452223
.alter p000055
.param VTHN=0.46083074780405536 VTHP=-0.47560107968651016 U0N=0.05003538221183406 U0P=0.019807636689720728 RDSWN=102.8492334112821 RDSWP=117.8515380838255 VSATN=85784.482785451066 VSATP=76696.667640823202 ETA0N=0.087820948609501709 ETA0P=0.080775886047891585 WS0=1.0357697897181193 WS1=1.0571671936330866 WS2=0.98994505906484143 WS3=0.99403002624672665
.alter p000056
.param VTHN=0.42112127232281038 VTHP=-0.43566367414251117 U0N=0.049459249700067022 U0P=0.01936357701329082 RDSWN=98.144376889060268 RDSWP=127.35043396187717 VSATN=87301.505219629151 VSATP=82644.295158891095 ETA0N=0.079852767745440312 ETA0P=0.072474350365891935 WS0=0.94371505373518938 WS1=1.0682225989983025 WS2=1.0389993853120634 WS3=0.9391652832396441
.alter p000057
.param VTHN=0.44739103112232775 VTHP=-0.43186220889832194 U0N=0.045201630518539503 U0P=0.018696456667809339 RDSWN=97.678579915815419 RDSWP=129.12780292306894 VSATN=84756.486491420888 VSATP=74518.689626259569 ETA0N=0.084344907069911768 ETA0P=0.082793600383146204 WS0=1.044846807148494 WS1=0.98506424887044453 WS2=1.0699998586606645 WS3=1.0702737002728449
.alter p000058
.param VTHN=0.47765026923166781 VTHP=-0.42456960285029766 U0N=0.052626597413023238 U0P=0.018525475353737629 RDSWN=108.96186528316366 RDSWP=130.6206647354559 VSATN=76455.714354369498 VSATP=76150.370419058963 ETA0N=0.078441470982163225 ETA0P=0.083071320282263258 WS0=1.0055197450770357 WS1=0.91460360770094207 WS2=0.94557847950196083 WS3=1.0227008825750035
.alter p000059
.param VTHN=0.42782936195148757 VTHP=-0.45381399566934838 U0N=0.054553662628066171 U0P=0.021607429190328601 RDSWN=108.64168365060777 RDSWP=126.92551078881017 VSATN=80840.828863179224 VSATP=86160.598222547036 ETA0N=0.080375233720796538 ETA0P=0.079654544303971883 WS0=1.0186891447741795 WS1=0.96912751736861202 WS2=1.0471431201783497 WS3=0.9465336716459003
.alter p000060
.param VTHN=0.43573262824976366 VTHP=-0.45179921948871271 U0N=0.053600206917510454 U0P=0.020264216999158959 RDSWN=90.52341294103033 RDSWP=109.63954297405903 VSATN=76929.674942070138 VSATP=72512.928321015657 ETA0N=0.082257325940310627 ETA0P=0.081909291069649268 WS0=0.93167660236457028 WS1=0.93470374805056167 WS2=0.99685557201789088 WS3=1.0452173688047444
.alter p000061
.param VTHN=0.45209322642141458 VTHP=-0.44513937859169328 U0N=0.046998136559248067 U0P=0.021037883516887384 RDSWN=97.912412029457812 RDSWP=115.31661154535001 VSATN=73965.317969103678 VSATP=83906.162433474674 ETA0N=0.073397723594617006 ETA0P=0.075610251640821302 WS0=1.0271805168301902 WS1=1.0624473132254042 WS2=1.0523940333126918 WS3=1.0664038641415723
.alter p000062
.param VTHN=0.44409395126468215 VTHP=-0.46646069683433722 U0N=0.054962586686987031 U0P=0.020609485131663656 RDSWN=96.505450074519729 RDSWP=115.90932120173755 VSATN=73673.639670936798 VSATP=74796.700769743504 ETA0N=0.086064299923497622 ETA0P=0.082229378293768002 WS0=1.0887302884470511 WS1=0.95154624461382764 WS2=1.0581167245109602 WS3=0.98201681729807688
.alter p000063
.param VTHN=0.4761697314967443 VTHP=-0.45854432700188164 U0N=0.049358493600455487 U0P=0.020350777988055319 RDSWN=90.764692935672812 RDSWP=120.21220017963051 VSATN=79722.822856011146 VSATP=77602.706566105902 ETA0N=0.078584952830842394 ETA0P=0.075121716844235714 WS0=1.0730551381257183 WS1=1.0623891070626066 WS2=0.90291792297738083 WS3=1.0635534658666608
.alter p000064
.param VTHN=0.44961153398790688 VTHP=-0.44227410537116629 U0N=0.050266009140177662 U0P=0.01993158763894293 RDSWN=99.137876987175275 RDSWP=110.21321538118829 VSATN=79075.322638690079 VSATP=74978.15858703226 ETA0N=0.082657299669853065 ETA0P=0.087823421674454533 WS0=1.0423658939368023 WS1=1.0527322856028716 WS2=0.96522973287514457 WS3=1.0079896609007779
.alter p000065
.param VTHN=0.43395277092943801 VTHP=-0.45733786348499045 U0N=0.052911913547899696 U0P=0.020700422237308707 RDSWN=90.282875318485566 RDSWP=125.03497971562393 VSATN=77378.705806947939 VSATP=80244.754123112725 ETA0N=0.082023359186692568 ETA0P=0.072335598008562901 WS0=0.94244485833722391 WS1=0.98473652248695276 WS2=0.94594200222759373 WS3=1.0829606321253322
.alter p000066
.param VTHN=0.4641025561423654 VTHP=-0.45220961926539138 U0N=0.0544221838464332 U0P=0.018508362529940141 RDSWN=90.634895564177469 RDSWP=123.69858767834533 VSATN=76491.211361194146 VSATP=76359.268115175888 ETA0N=0.073260283648655722 ETA0P=0.076984190709043623 WS0=1.0697159170365709 WS1=1.0804950078952662 WS2=1.0587916486556379 WS3=0.9493817468492195
.alter p000067
.param VTHN=0.44489245777482983 VTHP=-0.44063199168011202 U0N=0.052155462230137381 U0P=0.018043984158917708 RDSWN=91.406917186812024 RDSWP=109.98573289664594 VSATN=83121.282773214509 VSATP=84385.155634436131 ETA0N=0.085627721267452162 ETA0P=0.07396575990532897 WS0=0.9779599497038195 WS1=1.049772823966969 WS2=1.019982460451069 WS3=0.92726990287219735
.alter p000068
.param VTHN=0.47880690760770828 VTHP=-0.46540035757883241 U0N=0.047506428865727264 U0P=0.019308150587917579 RDSWN=94.004945901241669 RDSWP=123.14965085833038 VSATN=87204.133045071387 VSATP=82794.319475345939 ETA0N=0.084760544669316443 ETA0P=0.076473476174523297 WS0=0.9900652767273026 WS1=0.95615873437870136 WS2=1.0877072542057751 WS3=0.95190831789922881
.alter p000069
.param VTHN=0.46505496112405986 VTHP=-0.43119489972865421 U0N=0.052117747525481574 U0P=0.01906756870715166 RDSWN=90.038369640353579 RDSWP=117.98795831772436 VSATN=82180.89395284465 VSATP=73726.316373589798 ETA0N=0.085858098254644369 ETA0P=0.07480563416455957 WS0=1.0773851025230441 WS1=1.0977484368818362 WS2=1.043273221734355 WS3=1.0223221847570889
.alter p000070
.param VTHN=0.44616488096316115 VTHP=-0.42774260396053537 U0N=0.045041714506013561 U0P=0.018968247014595211 RDSWN=92.82408896037461 RDSWP=115.11584622512586 VSATN=77116.78100720112 VSATP=81721.445801054622 ETA0N=0.086599821557929252 ETA0P=0.084141094523069795 WS0=0.94126597568292625 WS1=1.0768453942711715 WS2=1.0910943332111376 WS3=1.0821734510491525
.alter p000071
.param VTHN=0.44391902727497007 VTHP=-0.4619494696429422 U0N=0.050373445028829469 U0P=0.01838789851602577 RDSWN=107.39585829516369 RDSWP=118.51557799705493 VSATN=74236.19735520528 VSATP=83237.615100818468 ETA0N=0.080104132031186201 ETA0P=0.077732246011781941 WS0=1.0704349616166973 WS1=1.0382085739007616 WS2=0.94786944643142956 WS3=0.90773990513606417
.alter p000072
.param VTHN=0.45604362312797003 VTHP=-0.46424414641378803 U0N=0.051022589748719149 U0P=0.018888122711678293 RDSWN=90.930563773167606 RDSWP=123.99958722141969 VSATN=73608.224647189461 VSATP=76918.586789702225 ETA0N=0.075944770009705759 ETA0P=0.086170038055615558 WS0=0.98218972643926883 WS1=0.95540204731731737 WS2=0.95938861722367519 WS3=0.99948392726853708
.alter p000073
.param VTHN=0.46863858272020043 VTHP=-0.44244366002862096 U0N=0.053872695483888663 U0P=0.0196487863746579 RDSWN=105.5906170353698 RDSWP=130.05877542077937 VSATN=82355.301237063584 VSATP=87558.308342531833 ETA0N=0.083616601275270624 ETA0P=0.084240566517857884 WS0=0.93843758982255787 WS1=0.93669987942250921 WS2=1.0299893353687737 WS3=1.0152480009186822
.alter p000074
.param VTHN=0.47759019487477683 VTHP=-0.47137473833924332 U0N=0.047972032163013989 U0P=0.02093536939254495 RDSWN=92.32358908617249 RDSWP=118.3801218583218 VSATN=83955.063842309159 VSATP=83102.686759345816 ETA0N=0.087342486737362127 ETA0P=0.08321842645928243 WS0=0.95517528063245505 WS1=0.93030941725110239 WS2=1.0933613344725897 WS3=0.93782341853838191
.alter p000075
.param VTHN=0.45457217835575148 VTHP=-0.46157039028015573 U0N=0.048322301454096751 U0P=0.01900086614661986 RDSWN=101.05743703578439 RDSWP=127.7579441646548 VSATN=76863.334601786031 VSATP=77869.876588762592 ETA0N=0.084536921299547471 ETA0P=0.074937328493146035 WS0=1.0355046254190867 WS1=1.0667522116249128 WS2=0.97029542661209034 WS3=1.066196895187919
.alter p000076
.param VTHN=0.46042449983096362 VTHP=-0.46762009768533769 U0N=0.045751865743166711 U0P=0.018998144629446295 RDSWN=109.07826877506474 RDSWP=120.1050284406747 VSATN=86334.037946847937 VSATP=77398.760234895715 ETA0N=0.083037168072675638 ETA0P=0.087437665183457372 WS0=1.0834069570349247 WS1=1.0778998058335127 WS2=1.0974192609997555 WS3=1.0437565550964205
.alter p000077
.param VTHN=0.45391379626695566 VTHP=-0.44717955607713877 U0N=0.051092542032677629 U0P=0.021968269237159777 RDSWN=95.535129233557043 RDSWP=119.71111725041574 VSATN=74662.523795264395 VSATP=85208.762231920686 ETA0N=0.082962297934448634 ETA0P=0.087645075810632619 WS0=1.0349171812591211 WS1=0.994355883802581 WS2=1.0995769926159937 WS3=0.96855273709194345
.alter p000078
.param VTHN=0.46981929715137322 VTHP=-0.4589773338201244 U0N=0.04661057178640815 U0P=0.020387324242097563 RDSWN=92.44946721352548 RDSWP=129.88542373198854 VSATN=72014.491771212022 VSATP=84660.229813960716 ETA0N=0.080505678705331249 ETA0P=0.07543791483274602 WS0=0.9388322964419733 WS1=1.016401241329026 WS2=0.92051082433204723 WS3=1.0675681662398815
.alter p000079
.param VTHN=0.45001230529695058 VTHP=-0.47735559406834327 U0N=0.048653391566843458 U0P=0.018826000766893954 RDSWN=93.418462047630598 RDSWP=124.90729142406553 VSATN=82046.899182433641 VSATP=83286.729663133621 ETA0N=0.085457459111114936 ETA0P=0.080547191652663178 WS0=1.0672999870699982 WS1=0.91507638066840169 WS2=0.98392922183670306 WS3=0.93832745425728215
.alter p000080
.param VTHN=0.43179513437021816 VTHP=-0.42810394727677142 U0N=0.049226032754452177 U0P=0.021958698056729897 RDSWN=99.380689152921292 RDSWP=128.86295346550401 VSATN=84654.720208803847 VSATP=74761.052776426732 ETA0N=0.078206853944812804 ETA0P=0.076877622050011585 WS0=0.92022158173691593 WS1=1.0308474057613048 WS2=1.0547451579825817 WS3=1.0171749162845631
.alter p000081
.param VTHN=0.46308860847526084 VTHP=-0.45499841460245605 U0N=0.048591425031158299 U0P=0.018499839877220255 RDSWN=97.534100795121901 RDSWP=128.54116560216843 VSATN=84371.749021445168 VSATP=72157.282135476577 ETA0N=0.077058671949227192 ETA0P=0.08094144400145771 WS0=1.0064424710408002 WS1=1.01519493480995 WS2=0.9078118149936435 WS3=1.0162858694754391
.alter p000082
.param VTHN=0.44008383386959826 VTHP=-0.4257612949290403 U0N=0.050532303052410854 U0P=0.020694320980173698 RDSWN=100.05513554830392 RDSWP=113.55083817063317 VSATN=84420.556916409201 VSATP=85665.552376113439 ETA0N=0.083932025032156077 ETA0P=0.076525045096892119 WS0=0.97220837466336585 WS1=1.0829656811362729 WS2=1.0169970733050255 WS3=1.0750735091549364
.alter p000083
.param VTHN=0.44678503161298394 VTHP=-0.4403362055171271 U0N=0.054630425134012311 U0P=0.018065324846080533 RDSWN=92.066809885654564 RDSWP=121.96830580555593 VSATN=78627.098969676415 VSATP=77571.086277557508 ETA0N=0.084105601143342673 ETA0P=0.075768582951068267 WS0=1.0117501094821837 WS1=0.90738870954132478 WS2=1.0109910532307866 WS3=0.96157359852847446
.alter p000084
.param VTHN=0.42519664108699845 VTHP=-0.43285923115064034 U0N=0.054779538323085276 U0P=0.02166388297681341 RDSWN=100.12382131784211 RDSWP=118.16981395363752 VSATN=84095.937523018438 VSATP=79185.704024570179 ETA0N=0.080596681737628031 ETA0P=0.072981274615769531 WS0=1.027812168174127 WS1=0.98066544740150929 WS2=1.0360126630037141 WS3=0.94346205788785098
.alter p000085
.param VTHN=0.42282373450531968 VTHP=-0.44612781359275877 U0N=0.047399052883125029 U0P=0.021156991833585811 RDSWN=96.540440067122873 RDSWP=111.21813153510615 VSATN=72051.971084540026 VSATP=85622.491934363716 ETA0N=0.078068804360272914 ETA0P=0.084788063175286393 WS0=0.90848978740549535 WS1=1.011759236571266 WS2=1.0592995431187053 WS3=0.99171357692278383
.alter p000086
.param VTHN=0.43212135412214775 VTHP=-0.46523287113551365 U0N=0.054376461118064906 U0P=0.019901584249713004 RDSWN=94.402882932935967 RDSWP=130.1817237266697 VSATN=77054.89302580306 VSATP=87352.630261734128 ETA0N=0.078684861645009901 ETA0P=0.079515411858744722 WS0=0.95795262651483548 WS1=1.0426549329465666 WS2=1.0607108758484367 WS3=1.0705245437206834
.alter p000087
.param VTHN=0.4370501327493449 VTHP=-0.42649520150636988 U0N=0.050844398783904989 U0P=0.020019809480256289 RDSWN=104.89575946049285 RDSWP=119.16901191404726 VSATN=84168.318506385724 VSATP=86868.265652075148 ETA0N=0.076528269604693805 ETA0P=0.086326453698323563 WS0=1.0619541117848741 WS1=0.97226860112103008 WS2=0.91264181773206898 WS3=0.98240625070473264
.alter p000088
.param VTHN=0.46256029511972735 VTHP=-0.43626069042629145 U0N=0.053916848509133079 U0P=0.019341396233433568 RDSWN=102.12645903817533 RDSWP=129.00016328648027 VSATN=79910.573456169019 VSATP=86706.086123833113 ETA0N=0.072189879633051957 ETA0P=0.078024775158409124 WS0=0.97139198432553631 WS1=1.0546456490608054 WS2=1.0181126309506208 WS3=0.93028082521188227
.alter p000089
.param VTHN=0.47466835364697946 VTHP=-0.4513865348560625 U0N=0.051842922200661362 U0P=0.021925728473034055 RDSWN=101.59346773799876 RDSWP=110.26020363135976 VSATN=83550.602667573374 VSATP=78027.176438307928 ETA0N=0.083129675956672047 ETA0P=0.083506074382652409 WS0=1.0735663854564164 WS1=1.0338380950095996 WS2=1.0600893913388412 WS3=1.0129427212440112
.alter p000090
.param VTHN=0.42696290315731833 VTHP=-0.45509655688930717 U0N=0.047674627400721974 U0P=0.020171746970856413 RDSWN=99.517535384582871 RDSWP=122.39812629184232 VSATN=73719.376672752987 VSATP=77888.211599775997 ETA0N=0.083895488498128848 ETA0P=0.074782850014141575 WS0=1.0162295602646405 WS1=0.98610157355356987 WS2=1.0375501751854519 WS3=0.95609212178837166
.alter p000091
.param VTHN=0.46578317914892192 VTHP=-0.46774706506857161 U0N=0.050984866873692455 U0P=0.021281436908375397 RDSWN=94.923005978735148 RDSWP=112.00093849925879 VSATN=79338.345075555422 VSATP=81634.780976445414 ETA0N=0.082458154374572712 ETA0P=0.076381381340577856 WS0=0.90825406391593566 WS1=1.0040940487314156 WS2=0.92345727404550515 WS3=0.98089486154164651
.alter p000092
.param VTHN=0.46244366391349684 VTHP=-0.44826530004278475 U0N=0.045561191235258508 U0P=0.020905617758436475 RDSWN=90.086979620963419 RDSWP=123.45184585182801 VSATN=79900.25173899479 VSATP=84121.239670013965 ETA0N=0.080544596265470475 ETA0P=0.083347296019077005 WS0=1.0204030933288246 WS1=0.99846734117790936 WS2=0.91565258387599568 WS3=1.0730835368379861
.alter p000093
.param VTHN=0.43041259993800779 VTHP=-0.47023814890738297 U0N=0.045831402386502018 U0P=0.0218457278091264 RDSWN=107.25848600919167 RDSWP=123.407705352817 VSATN=86463.452329568434 VSATP=80619.058417350534 ETA0N=0.084612762596901814 ETA0P=0.087729379734553692 WS0=1.0259004439289221 WS1=1.0838533512363282 WS2=0.97382492354860906 WS3=1.0695267210151733
.alter p000094
.param VTHN=0.44178762656224541 VTHP=-0.47771303604693449 U0N=0.051188634817306074 U0P=0.018948043835920723 RDSWN=95.377058024095362 RDSWP=113.40713384790244 VSATN=85127.472844687654 VSATP=79922.430702662023 ETA0N=0.072304559663896928 ETA0P=0.087867311365476264 WS0=0.91821925177067154 WS1=1.0518915080634685 WS2=1.0795403586943628 WS3=1.0124716132372162
.alter p000095
.param VTHN=0.44189636612821087 VTHP=-0.47371462953382909 U0N=0.047559356742999194 U0P=0.019451059814094382 RDSWN=90.597533341178078 RDSWP=125.91331475541064 VSATN=81442.084384707807 VSATP=83795.635943182875 ETA0N=0.076731659127970961 ETA0P=0.083303876834694202 WS0=1.0442030315828528 WS1=1.0867093399299543 WS2=1.0526711634350667 WS3=0.99291313620836319
.alter p000096
.param VTHN=0.45744544754431365 VTHP=-0.46531447188710151 U0N=0.052347823026535303 U0P=0.019072817531461447 RDSWN=95.220507165358981 RDSWP=119.94227278800126 VSATN=73344.229842769782 VSATP=87540.59554561344 ETA0N=0.082786503310962656 ETA0P=0.073885379172452748 WS0=1.0175427468870069 WS1=0.97429111675494828 WS2=1.0962600787860035 WS3=0.90805780990094331
.alter p000097
.param VTHN=0.44634089982700315 VTHP=-0.46181146572371085 U0N=0.046172532040590658 U0P=0.021174965763096517 RDSWN=108.19110924264199 RDSWP=120.3016122108038 VSATN=80424.079419609741 VSATP=81846.827937235372 ETA0N=0.075735284484670498 ETA0P=0.073406856053151739 WS0=0.92298204412398555 WS1=0.95955579846371064 WS2=1.04807433079473 WS3=0.97931278203907024
.alter p000098
.param VTHN=0.45915032464393379 VTHP=-0.43888888034856527 U0N=0.04770826997285648 U0P=0.020278514456032886 RDSWN=101.18275969283999 RDSWP=131.40968877106283 VSATN=85256.901610303961 VSATP=73160.057887956049 ETA0N=0.080257899107872344 ETA0P=0.08000591159016239 WS0=1.0321119227046107 WS1=1.0604955590479483 WS2=0.950182894699661 WS3=0.92985367332163515
.alter p000099
.param VTHN=0.44658949988151919 VTHP=-0.45528501866956128 U0N=0.053638801799752278 U0P=0.019316156920155383 RDSWN=105.33564772378222 RDSWP=126.17819599411472 VSATN=79177.749646082593 VSATP=72896.155761992806 ETA0N=0.087902231920701637 ETA0P=0.073987155409042049 WS0=0.90195021054880153 WS1=1.0506398296008628 WS2=1.0259575807962253 WS3=1.0602229693190615
.alter p000100
.param VTHN=0.44845545611310117 VTHP=-0.46470887518068904 U0N=0.049582862469241637 U0P=0.018938236376359236 RDSWN=103.24961368710113 RDSWP=113.031573681624 VSATN=78837.719720976063 VSATP=76441.904563253978 ETA0N=0.082487176161571599 ETA0P=0.078348637912114522 WS0=1.0667822770768227 WS1=0.97668263551690038 WS2=0.93345773676212818 WS3=1.0490096338202279
.alter p000101
.param VTHN=0.47345612361848716 VTHP=-0.45465309923983088 U0N=0.048146092174381705 U0P=0.018241564283038685 RDSWN=108.01391136298781 RDSWP=120.3480465429336 VSATN=73247.120513889167 VSATP=82883.267253606798 ETA0N=0.080959079891342101 ETA0P=0.087696956272069804 WS0=0.91247521786375319 WS1=0.99737001434433603 WS2=1.0467165386547643 WS3=0.9268400047804296
.alter p000102
.param VTHN=0.47705251347659644 VTHP=-0.46055884151996962 U0N=0.052841160665192594 U0P=0.020842525131514689 RDSWN=102.54397808797756 RDSWP=118.96523030368515 VSATN=80176.825215858989 VSATP=87111.53752314538 ETA0N=0.083426107029756197 ETA0P=0.086781572354275124 WS0=0.90662683154483115 WS1=0.95971478659954601 WS2=1.0722390556672052 WS3=0.98037896727363094
.alter p000103
.param VTHN=0.43447956784017799 VTHP=-0.43753972883275577 U0N=0.049772568235721112 U0P=0.019446894090789438 RDSWN=94.910641824388463 RDSWP=111.43439973607344 VSATN=80726.07539218622 VSATP=76298.220843395873 ETA0N=0.083608479443823255 ETA0P=0.084347738859392118 WS0=0.99222481313728972 WS1=0.94423039087930571 WS2=1.0377017889136337 WS3=1.0442327874883315
.alter p000104
.param VTHN=0.43819566805821308 VTHP=-0.4632229682325808 U0N=0.048118689750440861 U0P=0.021654194751445151 RDSWN=93.813127781542775 RDSWP=125.22216065995606 VSATN=81220.759813735887 VSATP=79603.615821588784 ETA0N=0.084578160914086209 ETA0P=0.07961639234283599 WS0=1.0037950369568824 WS1=0.94850841357821802 WS2=0.92251069410667363 WS3=1.0239110842340284
.alter p000105
.param VTHN=0.44465927394034166 VTHP=-0.46730194204476616 U0N=0.046746879118416906 U0P=0.020954147583286065 RDSWN=93.973395213844597 RDSWP=119.51019537699638 VSATN=80758.769404819381 VSATP=76786.353996241407 ETA0N=0.087256660309214973 ETA0P=0.082455197844691935 WS0=0.95602858819756054 WS1=0.97067997055010746 WS2=1.0647890840257035 WS3=1.039083495611548
.alter p000106
.param VTHN=0.43522093247059518 VTHP=-0.45940767223119433 U0N=0.053733488234890922 U0P=0.02139627044375516 RDSWN=93.272107121122559 RDSWP=111.04471391273383 VSATN=80344.663587271643 VSATP=86227.195176226509 ETA0N=0.07738923578922241 ETA0P=0.072556479789858408 WS0=1.0233187756879323 WS1=0.97396590859000221 WS2=0.90810786512724528 WS3=1.0557220616727645
.alter p000107
.param VTHN=0.42670622396752234 VTHP=-0.47926173494138152 U0N=0.049219135941216734 U0P=0.018988485082164552 RDSWN=107.8400978237425 RDSWP=130.31021588702779 VSATN=87919.68567068594 VSATP=86961.351880464295 ETA0N=0.075129116863029394 ETA0P=0.074471846589279397 WS0=0.98844565584664512 WS1=1.0669751095737969 WS2=0.99021442551026018 WS3=0.99022368281032724
.alter p000108
.param VTHN=0.47212718352741939 VTHP=-0.4308709487920323 U0N=0.05485908889537195 U0P=0.02172604637161564 RDSWN=93.32204353731143 RDSWP=120.55393069379815 VSATN=87583.142352713359 VSATP=86635.254771381646 ETA0N=0.072152388156332889 ETA0P=0.078624128636624213 WS0=1.0797002271809462 WS1=0.95241514154370543 WS2=0.92190914385202161 WS3=0.97767110185816075
.alter p000109
.param VTHN=0.45021786151043502 VTHP=-0.46711549267676744 U0N=0.047003340973463009 U0P=0.018400048553146104 RDSWN=94.083457508763473 RDSWP=120.44774505988021 VSATN=81372.330390450486 VSATP=83363.939010140661 ETA0N=0.077373767437996732 ETA0P=0.083848877969463484 WS0=1.0224471864606364 WS1=1.0063680876421803 WS2=1.0069350857855557 WS3=0.95867324998422621
.alter p000110
.param VTHN=0.47160861700641887 VTHP=-0.47446785142051268 U0N=0.054085823798556545 U0P=0.019708050719353935 RDSWN=91.265952261190478 RDSWP=115.26439496446417 VSATN=73752.585333752009 VSATP=82967.367986117155 ETA0N=0.072563123038151933 ETA0P=0.087461573863725051 WS0=1.0954333042528031 WS1=0.97485957254799915 WS2=1.012799377855085 WS3=0.98045724933145784
.alter p000111
.param VTHN=0.472509771575157 VTHP=-0.45469281717342236 U0N=0.049469310257575005 U0P=0.021528521271557605 RDSWN=104.63435085629003 RDSWP=110.5772470295601 VSATN=84991.875536490683 VSATP=83035.988861624355 ETA0N=0.078429330296489935 ETA0P=0.077589560623818443 WS0=0.97835800436680787 WS1=0.96651080216527441 WS2=0.96192693042693689 WS3=1.089616987048057
.alter p000112
.param VTHN=0.42855383889038567 VTHP=-0.46293187831685512 U0N=0.0460650557163617 U0P=0.018274419413374373 RDSWN=106.30087274434158 RDSWP=125.89779435957247 VSATN=85020.618990974879 VSATP=74420.041585213432 ETA0N=0.084064729452513656 ETA0P=0.086047075249212748 WS0=1.0305743516277963 WS1=0.95759055937535342 WS2=0.91661893233228842 WS3=0.90211707174844213
.alter p000113
.param VTHN=0.44316674438073228 VTHP=-0.45568475042685264 U0N=0.046928153550185765 U0P=0.019221694518006413 RDSWN=96.701402202250947 RDSWP=108.46220183832077 VSATN=83217.737598401363 VSATP=79042.408003514473 ETA0N=0.087537751229084096 ETA0P=0.081701680190118406 WS0=1.050587747661355 WS1=0.9447932478016533 WS2=1.0578773105003614 WS3=0.9025765268157665
.alter p000114
.param VTHN=0.43458245003043228 VTHP=-0.47115846526759303 U0N=0.046277760176813995 U0P=0.020101312661930909 RDSWN=103.12374665764584 RDSWP=123.07782060157278 VSATN=83316.20854048153 VSATP=80576.614127846944 ETA0N=0.085205773448216365 ETA0P=0.073636514242399712 WS0=0.93593275121362107 WS1=1.0532923751295626 WS2=1.0802170423170485 WS3=0.90881157259145584
.alter p000115
.param VTHN=0.44093036772030642 VTHP=-0.43992665408038356 U0N=0.046526172179833736 U0P=0.019042243741465258 RDSWN=100.48993034315401 RDSWP=118.81296956853765 VSATN=77844.133244699668 VSATP=86037.63475663634 ETA0N=0.087136364658447776 ETA0P=0.074632338921941252 WS0=1.041682209003328 WS1=1.0204211706390092 WS2=0.93898467653523898 WS3=1.0890506895076237
.alter p000116
.param VTHN=0.47690868800957315 VTHP=-0.47599834511814626 U0N=0.04500884019225268 U0P=0.018567099679110608 RDSWN=99.607113297342551 RDSWP=111.83769092706051 VSATN=77338.226447680223 VSATP=85008.925242520781 ETA0N=0.072527267617211982 ETA0P=0.083948679282980013 WS0=1.0841255777565222 WS1=0.9265243194920163 WS2=1.0855349691039473 WS3=1.0857125375761345
.alter p000117
.param VTHN=0.42655707284005634 VTHP=-0.42156071422848196 U0N=0.052998844282327096 U0P=0.020516259164060309 RDSWN=96.661734977997469 RDSWP=122.16200308775191 VSATN=76918.250752314023 VSATP=84055.95669605468 ETA0N=0.081208348176877859 ETA0P=0.086715959135275786 WS0=1.0290577651430688 WS1=1.0121221351661469 WS2=0.97052572275949101 WS3=0.93584254170575742
.alter p000118
.param VTHN=0.4569942003478093 VTHP=-0.4778028526888653 U0N=0.045073163323231628 U0P=0.018791342124751264 RDSWN=92.604791759678164 RDSWP=124.87465003178852 VSATN=87087.667001302485 VSATP=86423.82602780599 ETA0N=0.073132018755268383 ETA0P=0.079087591185618478 WS0=1.0576290624150793 WS1=0.99115975932303801 WS2=1.0075518441155253 WS3=1.0430996602681875
.alter p000119
.param VTHN=0.47279801186821829 VTHP=-0.44302573105981502 U0N=0.051268726725025762 U0P=0.018235272588688685 RDSWN=92.969836131047771 RDSWP=121.92456759185509 VSATN=74993.180381117854 VSATP=86296.096118439018 ETA0N=0.086477127695582856 ETA0P=0.086617748130687733 WS0=1.0457474929114576 WS1=0.95785175106901987 WS2=1.0317481808548754 WS3=1.0797979910171751
.alter p000120
.param VTHN=0.42614549693500703 VTHP=-0.42884303794489614 U0N=0.05306102039701184 U0P=0.018638318069528353 RDSWN=91.498051152577034 RDSWP=117.71028045102689 VSATN=86094.67791258925 VSATP=83744.482737217244 ETA0N=0.080818886660269415 ETA0P=0.076704419009063426 WS0=0.94666495896446234 WS1=0.97798296559557263 WS2=0.96009977915889988 WS3=0.97158864822896585
.alter p000121
.param VTHN=0.44373627028949852 VTHP=-0.47357452975689379 U0N=0.048757050240632219 U0P=0.020300896129208556 RDSWN=102.9498047119373 RDSWP=129.48734223173719 VSATN=82666.096625658654 VSATP=78465.112782721888 ETA0N=0.077311391836379958 ETA0P=0.086513029702193794 WS0=0.99193299155110315 WS1=1.0512691196768964 WS2=0.99647026324299703 WS3=0.95298355557218728
.alter p000122
.param VTHN=0.45134067305044023 VTHP=-0.474019410137201 U0N=0.053194569589878782 U0P=0.020651009682781902 RDSWN=102.26199158188278 RDSWP=113.68712549764794 VSATN=84393.061341213397 VSATP=78383.520756057565 ETA0N=0.081315083017746703 ETA0P=0.073486918083379316 WS0=0.95401775395318977 WS1=0.96772898096296922 WS2=0.96756954812772766 WS3=1.0107481264329139
.alter p000123
.param VTHN=0.44200139699150137 VTHP=-0.46921853496068211 U0N=0.050687103875723366 U0P=0.021121606004961838 RDSWN=94.183409170338749 RDSWP=124.19841917188842 VSATN=79493.973105836441 VSATP=73936.19617951689 ETA0N=0.086802100273350141 ETA0P=0.084412847229703755 WS0=0.93979311672826815 WS1=0.91723830208908208 WS2=0.95135912801422229 WS3=1.0046771269619423
.alter p000124
.param VTHN=0.43693114059348098 VTHP=-0.47331771703420233 U0N=0.0466200757444045 U0P=0.021779759074508596 RDSWN=95.671694510207033 RDSWP=121.727024643847 VSATN=84223.516791985021 VSATP=80799.45359301538 ETA0N=0.076766566938173575 ETA0P=0.075471920091643552 WS0=1.0962417303496013 WS1=0.96208293452039428 WS2=1.0619785025518385 WS3=1.0339619243328124
.alter p000125
.param VTHN=0.42778725420661046 VTHP=-0.47417521309645749 U0N=0.054510211155707616 U0P=0.019416948774166384 RDSWN=103.7865974962138 RDSWP=122.02402939495828 VSATN=79629.559802411168 VSATP=78321.851782735233 ETA0N=0.079097639938769546 ETA0P=0.07295377912584157 WS0=1.063263271685968 WS1=0.91609723831957912 WS2=0.9762861376207298 WS3=0.97032445715313531
.alter p000126
.param VTHN=0.45371268451254831 VTHP=-0.42496861554317339 U0N=0.0471580069587475 U0P=0.020456366242641914 RDSWN=105.10777482857584 RDSWP=126.52021631490248 VSATN=74359.447344254135 VSATP=76895.345493827859 ETA0N=0.086549400637251458 ETA0P=0.072587471093596159 WS0=0.99947512633390412 WS1=1.0949300958419086 WS2=1.0145323332345479 WS3=1.0506961246705393
.alter p000127
.param VTHN=0.44240276525935096 VTHP=-0.4650748027398372 U0N=0.053399063012708345 U0P=0.018122392902451424 RDSWN=92.398174609042272 RDSWP=130.69224326212009 VSATN=87481.948166146714 VSATP=79528.359850412904 ETA0N=0.076956428161801593 ETA0P=0.085827804050662759 WS0=1.088854729122769 WS1=1.0887650174703389 WS2=1.0286169575054336 WS3=1.0198969659822446
.alter p000128
.param VTHN=0.42489593464797298 VTHP=-0.46955981763804955 U0N=0.052920581834403631 U0P=0.019559955097445458 RDSWN=96.0953951135171 RDSWP=121.00940521692196 VSATN=73337.770992444246 VSATP=81977.174968901396 ETA0N=0.081871394931632049 ETA0P=0.084485885902491009 WS0=1.0393157285217847 WS1=1.0170733707977551 WS2=0.95108715646078024 WS3=1.0515335119725489
.alter p000129
.param VTHN=0.47307829346559793 VTHP=-0.43683726974984105 U0N=0.048929254502939307 U0P=0.018308380025240285 RDSWN=103.48540914434022 RDSWP=110.80210246686252 VSATN=73471.39876574892 VSATP=85271.532016633908 ETA0N=0.076090762486235392 ETA0P=0.077337054651477263 WS0=0.90227104095623734 WS1=0.97144130827985264 WS2=1.0649895084312553 WS3=1.0567554379045208
.alter p000130
.param VTHN=0.45429694246077473 VTHP=-0.46105645661669115 U0N=0.053296226086674704 U0P=0.020135097243124272 RDSWN=100.38714321331221 RDSWP=124.42215751364955 VSATN=77308.708484125702 VSATP=74096.30048962454 ETA0N=0.084188783690721719 ETA0P=0.087655320739173301 WS0=1.0166302368411129 WS1=1.0715647287141827 WS2=1.0473797041031885 WS3=0.96565922501971657
.alter p000131
.param VTHN=0.46944339739965696 VTHP=-0.43487202341406722 U0N=0.051742196677583459 U0P=0.018225975086118559 RDSWN=104.97574536354502 RDSWP=122.57208802263827 VSATN=73893.918313055925 VSATP=79210.568811385223 ETA0N=0.083197984537904918 ETA0P=0.079003518099192385 WS0=0.92833415428695654 WS1=1.0196098378187242 WS2=0.96715583355237877 WS3=0.98385423043479281
.alter p000132
.param VTHN=0.4697614517552931 VTHP=-0.44204743064679969 U0N=0.048979333222022484 U0P=0.019355825596137775 RDSWN=95.499074125004626 RDSWP=122.80761654590685 VSATN=86580.211446392495 VSATP=72488.691705837598 ETA0N=0.073357134320854972 ETA0P=0.083825063853809584 WS0=1.0425327181970852 WS1=1.0493387860443892 WS2=1.0273055197872516 WS3=1.097330491778453
.alter p000133
.param VTHN=0.44823613500833703 VTHP=-0.45812035272522644 U0N=0.045708024899417672 U0P=0.018957465451318781 RDSWN=90.461267013194899 RDSWP=111.47103268877856 VSATN=78111.386803157438 VSATP=78741.217679989524 ETA0N=0.074999212379770974 ETA0P=0.076940165415732217 WS0=0.94908033643977541 WS1=0.99209793218412501 WS2=0.97533613572313138 WS3=1.0122854552393783
.alter p000134
.param VTHN=0.47678663015767181 VTHP=-0.43899588848931337 U0N=0.051721836726895495 U0P=0.020258402684936193 RDSWN=90.700586167909989 RDSWP=109.4754091393514 VSATN=75526.173944374299 VSATP=76028.006276344357 ETA0N=0.079668214368697393 ETA0P=0.07600146147429003 WS0=0.9863471421611798 WS1=1.0399391821357782 WS2=1.0370366388213619 WS3=1.0035769263418772
.alter p000135
.param VTHN=0.46397097369677148 VTHP=-0.47977376930093268 U0N=0.04668699721466589 U0P=0.019496371485130896 RDSWN=96.598471166366963 RDSWP=115.79923627362744 VSATN=74260.890979956006 VSATP=73858.948891099833 ETA0N=0.08107962831162463 ETA0P=0.085258092904081137 WS0=0.9270083685892615 WS1=0.99358606970098484 WS2=0.95067560077476887 WS3=1.0449753555194754
.alter p000136
.param VTHN=0.45237773989023172 VTHP=-0.46083995558386937 U0N=0.054595690650416411 U0P=0.019626530488456681 RDSWN=108.49164238273525 RDSWP=116.56430828091128 VSATN=86357.448189553557 VSATP=80180.280074735114 ETA0N=0.085651869225116681 ETA0P=0.08608714827995298 WS0=1.0473448036498132 WS1=1.0179076477571911 WS2=0.93637101909363984 WS3=0.9699181641348843
.alter p000137
.param VTHN=0.45513719348554726 VTHP=-0.42279062610972512 U0N=0.05242501434683168 U0P=0.018223373455137235 RDSWN=93.542288425672666 RDSWP=127.92931514004974 VSATN=84036.311453537142 VSATP=74656.748434186782 ETA0N=0.074654595759875 ETA0P=0.081027372499812969 WS0=1.0638044565281788 WS1=0.98555728360768313 WS2=0.99322107469658094 WS3=0.92630331735328431
.alter p000138
.param VTHN=0.4243592480073729 VTHP=-0.45919563611502989 U0N=0.050808039599826958 U0P=0.018691454419633803 RDSWN=93.443015090170263 RDSWP=129.25474872788769 VSATN=83616.117135979701 VSATP=78348.618981498381 ETA0N=0.082867912783648481 ETA0P=0.086951155841570385 WS0=1.0659771752192544 WS1=0.91091303718041017 WS2=1.0194514508639598 WS3=1.004152144977716
.alter p000139
.param VTHN=0.47158982320549581 VTHP=-0.44656355389257973 U0N=0.054018176802996566 U0P=0.018620236906683435 RDSWN=101.68905373551078 RDSWP=115.7099850293033 VSATN=74593.447855508173 VSATP=80114.550661414134 ETA0N=0.080343311417618107 ETA0P=0.081325242235887787 WS0=1.0106406409469681 WS1=1.0096760013104609 WS2=0.91138743546122236 WS3=1.0384157019921973
.alter p000140
.param VTHN=0.44838519273616478 VTHP=-0.43788768273877104 U0N=0.048069760407468992 U0P=0.018967865983360279 RDSWN=91.186446693588735 RDSWP=116.73732278905449 VSATN=79656.745033684332 VSATP=82580.506667551352 ETA0N=0.081486454333846103 ETA0P=0.075057655615347704 WS0=0.98170748601542068 WS1=1.047844802024503 WS2=0.94025549317054979 WS3=0.97292657469380794
.alter p000141
.param VTHN=0.44668328859530165 VTHP=-0.47651001093858608 U0N=0.053133741264101753 U0P=0.021453023016212366 RDSWN=106.00751484132994 RDSWP=108.05057150015158 VSATN=86536.382713654966 VSATP=87100.99564635061 ETA0N=0.08379752902320757 ETA0P=0.072247275684259149 WS0=1.070196662163575 WS1=0.92488423745851056 WS2=1.0558987370258801 WS3=1.0610659055987275
.alter p000142
.param VTHN=0.47929854594159643 VTHP=-0.43955449786189132 U0N=0.045082330787871876 U0P=0.019976933580454062 RDSWN=103.43017350312758 RDSWP=115.54534594839996 VSATN=80775.431017376177 VSATP=87172.411758431219 ETA0N=0.073696343312913762 ETA0P=0.074988652844178952 WS0=1.0407660643554604 WS1=1.0710029353097323 WS2=0.90556937745096933 WS3=1.0208800688710613
.alter p000143
.param VTHN=0.47579217903361004 VTHP=-0.44598782138573967 U0N=0.051051151555752398 U0P=0.020160197384603559 RDSWN=96.466293719278212 RDSWP=124.30504742354137 VSATN=85794.269151609711 VSATP=85721.550883433461 ETA0N=0.081173512011699339 ETA0P=0.077560656702119105 WS0=1.0644948386398188 WS1=0.9469509650500948 WS2=0.98687488554312031 WS3=1.030074957330102
.alter p000144
.param VTHN=0.45329343289203355 VTHP=-0.43112005960457955 U0N=0.047102046488187152 U0P=0.020053599433741021 RDSWN=96.326397628775155 RDSWP=111.1112368272637 VSATN=80888.828091115749 VSATP=74728.849652179997 ETA0N=0.073929097126432225 ETA0P=0.073152096175430795 WS0=0.90291247745996095 WS1=0.9363327393593881 WS2=0.99945929241786202 WS3=0.96507298803008812
.alter p000145
.param VTHN=0.43508556290302841 VTHP=-0.46600511296804265 U0N=0.050152918730477766 U0P=0.021919764130151415 RDSWN=105.29790706026331 RDSWP=118.74938215733157 VSATN=77356.070550176097 VSATP=85858.918554759221 ETA0N=0.072670089749718725 ETA0P=0.078872689799902654 WS0=1.0470408334789014 WS1=0.94661824620302448 WS2=1.0780872411558744 WS3=1.0421493959858652
.alter p000146
.param VTHN=0.42265122188667442 VTHP=-0.43496729683312285 U0N=0.046956004830384895 U0P=0.019155340110545285 RDSWN=102.81501325583311 RDSWP=122.29144220568736 VSATN=85534.762408325434 VSATP=78714.363890951834 ETA0N=0.08559861228739854 ETA0P=0.079907300877422108 WS0=0.95199919113421683 WS1=1.0129342620338402 WS2=0.94218626867159361 WS3=0.91794525796764825
.alter p000147
.param VTHN=0.42545323701159254 VTHP=-0.45077021136261641 U0N=0.054951738463788896 U0P=0.021718591275838271 RDSWN=95.817609429112011 RDSWP=117.82327893515104 VSATN=79203.509607892585 VSATP=74188.727084247017 ETA0N=0.084031872301312635 ETA0P=0.087560216978702171 WS0=1.0384816076503409 WS1=1.020938394068156 WS2=0.94715897748833811 WS3=1.0684781428314942
.alter p000148
.param VTHN=0.44309106147975247 VTHP=-0.42967501238157063 U0N=0.046193423016349877 U0P=0.020233660816083465 RDSWN=104.48270719521315 RDSWP=112.16281794017064 VSATN=83241.793742570095 VSATP=84517.346900986246 ETA0N=0.087116355173814539 ETA0P=0.087744990138671902 WS0=1.04783421537468 WS1=0.94150696398492761 WS2=0.94174210319769702 WS3=0.98573580362928526
.alter p000149
.param VTHN=0.478669169804951 VTHP=-0.45801852788351693 U0N=0.048014157590632593 U0P=0.018916615425889405 RDSWN=92.288685801238785 RDSWP=126.29466609624566 VSATN=81950.919611637495 VSATP=72969.324601861736 ETA0N=0.081357247380292902 ETA0P=0.081063078060546079 WS0=0.99708720280715868 WS1=0.97470779918404948 WS2=0.96967988432995811 WS3=1.0725216093477554
.alter p000150
.param VTHN=0.45695522394182708 VTHP=-0.46062558268533638 U0N=0.047079948157201276 U0P=0.018032720049011856 RDSWN=101.95762531358979 RDSWP=122.59924546601724 VSATN=79541.659986434432 VSATP=87627.73276218379 ETA0N=0.078047973341639945 ETA0P=0.077933911607219658 WS0=1.0653279554504829 WS1=1.0202679226714386 WS2=0.91921444095622928 WS3=0.91999141753355973
.alter p000151
.param VTHN=0.46206717820641241 VTHP=-0.47878648264629631 U0N=0.049379006607444625 U0P=0.019968279219980616 RDSWN=95.635829761708962 RDSWP=126.21100729078969 VSATN=76793.130375437599 VSATP=74285.121563081309 ETA0N=0.075423895196921664 ETA0P=0.074135994020639862 WS0=0.94579055566300241 WS1=0.93344839191592233 WS2=1.0930132774627768 WS3=1.0277914070227603
.alter p000152
.param VTHN=0.44059438622733327 VTHP=-0.42125034068224837 U0N=0.049284075221826706 U0P=0.020034252491347174 RDSWN=94.519018469837476 RDSWP=111.92017798945557 VSATN=81796.295155139436 VSATP=73544.630970265513 ETA0N=0.073562671007402339 ETA0P=0.085063009390696609 WS0=0.91192310192360149 WS1=1.0963141567574572 WS2=0.96412660648588044 WS3=1.0762528172831975
.alter p000153
.param VTHN=0.44331717165935092 VTHP=-0.44942910151624932 U0N=0.054662482726699102 U0P=0.020142181167747825 RDSWN=105.13662637628646 RDSWP=125.73377836373075 VSATN=82577.847402171101 VSATP=83177.936248173719 ETA0N=0.081800721062709289 ETA0P=0.08376628098242675 WS0=1.0340875710347077 WS1=1.0893253469495594 WS2=0.93039546797928285 WS3=0.99650214998509457
.alter p000154
.param VTHN=0.46134046245537563 VTHP=-0.44122652559905284 U0N=0.045955358765141091 U0P=0.021895636791233981 RDSWN=95.858914821939166 RDSWP=110.34443315504016 VSATN=76549.252757988404 VSATP=84768.463971168807 ETA0N=0.086734284752401442 ETA0P=0.075382121053564857 WS0=1.0868044246558839 WS1=1.0464936249837444 WS2=1.0919433453724123 WS3=0.94755656610807693
.alter p000155
.param VTHN=0.44714821986705777 VTHP=-0.430225226519791 U0N=0.053703196560468569 U0P=0.018793250231680832 RDSWN=96.28126491528154 RDSWP=114.07725835470798 VSATN=83010.486627566628 VSATP=72316.671798468451 ETA0N=0.076603563000008673 ETA0P=0.073455781927992236 WS0=1.0151703639015515 WS1=0.95847405432190425 WS2=1.0588306563348313 WS3=1.0885342798984239
.alter p000156
.param VTHN=0.42815431485917621 VTHP=-0.46118611628227041 U0N=0.04826882108990866 U0P=0.019520928548480591 RDSWN=104.06640271776095 RDSWP=130.57147342303176 VSATN=73132.473824361427 VSATP=87505.368551568157 ETA0N=0.085246467767982823 ETA0P=0.080636923318654963 WS0=0.90496694061853977 WS1=1.0274030688437326 WS2=1.0346861380893921 WS3=1.086212257020309
.alter p000157
.param VTHN=0.42741786818329597 VTHP=-0.47696355783126398 U0N=0.054608400199480392 U0P=0.019009101400241316 RDSWN=93.075906705785627 RDSWP=124.78354830913763 VSATN=72251.012332810642 VSATP=81668.926146609549 ETA0N=0.086280641223668408 ETA0P=0.073413942544454783 WS0=0.92763732392337084 WS1=0.93178375285636705 WS2=1.0805873448852394 WS3=0.96457131078006519
.alter p000158
.param VTHN=0.46378767121274028 VTHP=-0.4576091394002974 U0N=0.053422613043854546 U0P=0.021938330534230881 RDSWN=98.348304876440523 RDSWP=110.44591208360816 VSATN=80653.515412323759 VSATP=79479.029694353347 ETA0N=0.075196006043296806 ETA0P=0.079486385597751272 WS0=0.96018752335227364 WS1=1.0593142420462134 WS2=0.98676595511155507 WS3=1.08160972930716
.alter p000159
.param VTHN=0.42185165404734076 VTHP=-0.47900839632167402 U0N=0.046659035872299831 U0P=0.021058509853734909 RDSWN=100.3015510681014 RDSWP=117.06460693900378 VSATN=80141.905545961359 VSATP=73052.757848673369 ETA0N=0.086989906342393009 ETA0P=0.079265121447342796 WS0=1.0855002190012331 WS1=0.9654763727684772 WS2=0.97149491071889571 WS3=1.0955154722788436
.alter p000160
.param VTHN=0.47837163841410368 VTHP=-0.46171230004630603 U0N=0.045122898143027626 U0P=0.021525806057389005 RDSWN=90.988752652658263 RDSWP=123.89903453940822 VSATN=85317.305719436656 VSATP=81795.800642458533 ETA0N=0.075587585879130947 ETA0P=0.080999790866408267 WS0=1.0021701865286721 WS1=0.95676046489859046 WS2=1.0625420555441778 WS3=0.94391602325078239
.alter p000161
.param VTHN=0.47747085323983829 VTHP=-0.47210536338747705 U0N=0.046423786313156343 U0P=0.02028265620156228 RDSWN=101.32673165192303 RDSWP=126.04917359283297 VSATN=74711.133448677851 VSATP=78915.915664311862 ETA0N=0.078244908710399824 ETA0P=0.083378784099661887 WS0=1.0551072204142102 WS1=1.0404862700508113 WS2=1.0033549741969769 WS3=1.0281253040946734
.alter p000162
.param VTHN=0.42914226157881086 VTHP=-0.42829012747309042 U0N=0.048120676489071111 U0P=0.021303149530012531 RDSWN=94.279852231443101 RDSWP=129.10598007211175 VSATN=75945.961778470955 VSATP=84080.009276352823 ETA0N=0.073636518795162323 ETA0P=0.086853546174120555 WS0=0.98667057637570477 WS1=1.0294819521203027 WS2=0.9065300761019548 WS3=1.0849959902853921
.alter p000163
.param VTHN=0.45069891850966209 VTHP=-0.4485135802050253 U0N=0.051476749945055036 U0P=0.018625190669169185 RDSWN=98.028222031585187 RDSWP=124.49966831446653 VSATN=79563.594834301315 VSATP=72340.145561101628 ETA0N=0.081280391609963198 ETA0P=0.07761834230917708 WS0=1.000583602392455 WS1=0.99538249108980759 WS2=1.0082318169305229 WS3=0.99252499931801796
.alter p000164
.param VTHN=0.43628338650953091 VTHP=-0.42626960586937823 U0N=0.049794826624813479 U0P=0.020658532101523824 RDSWN=105.4368014956025 RDSWP=123.50442368982087 VSATN=75807.721679742783 VSATP=75043.971371754771 ETA0N=0.072078588844183139 ETA0P=0.078880137708513515 WS0=1.0623033825557742 WS1=0.91929526138961914 WS2=0.99053058591827181 WS3=0.91599389053310221
.alter p000165
.param VTHN=0.46771874546734044 VTHP=-0.44065359764594125 U0N=0.046589011066395729 U0P=0.019829219559140646 RDSWN=102.31310112877023 RDSWP=119.32272877865248 VSATN=77476.308069681021 VSATP=77652.96665213356 ETA0N=0.080893823556558206 ETA0P=0.075565275628822065 WS0=0.90911457232173121 WS1=1.0453482347419902 WS2=0.92470827252282384 WS3=0.91605538958244959
.alter p000166
.param VTHN=0.43913161418806596 VTHP=-0.4533999282897842 U0N=0.05251242923236682 U0P=0.021582960142943433 RDSWN=98.267254381703509 RDSWP=122.83674866355686 VSATN=87385.585567954768 VSATP=75882.700742797853 ETA0N=0.083076842496178652 ETA0P=0.079169169078265475 WS0=1.0823151598135712 WS1=0.94508029040879693 WS2=0.95916565537632492 WS3=1.0263089631040072
.alter p000167
.param VTHN=0.45932052907966697 VTHP=-0.42332967667742755 U0N=0.048791509484357495 U0P=0.01960019317267412 RDSWN=91.764968194529445 RDSWP=127.80997751608516 VSATN=81481.238798712511 VSATP=78891.960421211537 ETA0N=0.080690578744063504 ETA0P=0.075085664468098945 WS0=0.94540502345686428 WS1=0.94938684852086541 WS2=0.93285251543989356 WS3=1.0187299137762755
.alter p000168
.param VTHN=0.45259995425599919 VTHP=-0.4342493502599461 U0N=0.045319971289630202 U0P=0.021964615544090398 RDSWN=93.928083225565331 RDSWP=125.96201080685184 VSATN=78722.242350853368 VSATP=73273.583238891311 ETA0N=0.081140589185689338 ETA0P=0.082761989339837486 WS0=0.94825751923320434 WS1=1.0472611250910719 WS2=0.91083107094149951 WS3=1.0810193397332679
.alter p000169
.param VTHN=0.44381491825616426 VTHP=-0.45293550080060696 U0N=0.048615395573029338 U0P=0.021908743608858163 RDSWN=109.49769248479316 RDSWP=114.41312292674606 VSATN=80287.239104265012 VSATP=75632.00713321229 ETA0N=0.082316071219227169 ETA0P=0.08452498891514966 WS0=1.0297194916401402 WS1=0.9158033120329665 WS2=0.98111866649116153 WS3=0.92435482874529418
.alter p000170
.param VTHN=0.44418835123482409 VTHP=-0.4233645209964903 U0N=0.051517026971299285 U0P=0.021315810046712562 RDSWN=103.72630412903567 RDSWP=111.72855159412413 VSATN=81832.760356367449 VSATP=74345.291169792836 ETA0N=0.077488497441445869 ETA0P=0.073220782261735146 WS0=0.91111155408916755 WS1=1.0749864906350204 WS2=0.97305142003409006 WS3=1.0938300046498595
.alter p000171
.param VTHN=0.45295465661631051 VTHP=-0.4393911863365888 U0N=0.050867943578933573 U0P=0.019673314880561555 RDSWN=109.53601044034916 RDSWP=117.549295041997 VSATN=83458.044916208892 VSATP=84709.896385256259 ETA0N=0.085730302983474047 ETA0P=0.080039736688533716 WS0=1.091311017554337 WS1=0.97248126286635239 WS2=1.0818449381571376 WS3=1.0710949851711213
.alter p000172
.param VTHN=0.46903370560882923 VTHP=-0.47813401107569597 U0N=0.050775572821027008 U0P=0.020579482384911755 RDSWN=108.85961874108102 RDSWP=131.88977940208736 VSATN=86689.981933061295 VSATP=83490.906425748632 ETA0N=0.079051735275071727 ETA0P=0.075357584843960074 WS0=0.93149128525113722 WS1=1.0955757781382589 WS2=1.0573927531808127 WS3=1.0942959895966031
.alter p000173
.param VTHN=0.47538542077443552 VTHP=-0.44860427703558403 U0N=0.049642522813002563 U0P=0.021902378396307244 RDSWN=96.133083291460821 RDSWP=109.57494878116943 VSATN=81654.026310359244 VSATP=80737.262488596636 ETA0N=0.079032964737217437 ETA0P=0.079834344946433239 WS0=1.033794037600098 WS1=1.0321842611864114 WS2=1.0621834293360983 WS3=0.95004407466407437
.alter p000174
.param VTHN=0.4444841498981581 VTHP=-0.46232330548027567 U0N=0.046965733628338037 U0P=0.019720503060720589 RDSWN=109.35959531169838 RDSWP=109.90885469523788 VSATN=77909.690654996477 VSATP=77139.84947338968 ETA0N=0.084784822579122857 ETA0P=0.072744393216785996 WS0=1.076681359907314 WS1=1.0835483709767273 WS2=1.0664362622184362 WS3=1.0553385972797569
.alter p000175
.param VTHN=0.4519042830322339 VTHP=-0.45675505929725768 U0N=0.051600624944143865 U0P=0.020205519530405162 RDSWN=101.25443622534515 RDSWP=123.75254193626486 VSATN=74103.104794686835 VSATP=75601.982460984233 ETA0N=0.073490971192685203 ETA0P=0.077363903946620433 WS0=1.0014126771045353 WS1=0.9210173407197606 WS2=0.96677907757341519 WS3=0.94214326116146185
.alter p000176
.param VTHN=0.47558663360864384 VTHP=-0.4304524645973109 U0N=0.053963723131979141 U0P=0.021487440600750439 RDSWN=101.41752524032979 RDSWP=115.03218223081511 VSATN=76889.30657916193 VSATP=73137.286054904107 ETA0N=0.078138694403183315 ETA0P=0.076049681437552419 WS0=0.90938871796000142 WS1=0.90472173296404601 WS2=0.95321624475428435 WS3=1.0213889592520722
.alter p000177
.param VTHN=0.47063345832133413 VTHP=-0.42449597639257608 U0N=0.047590617284636587 U0P=0.01961674024635511 RDSWN=106.20440041346889 RDSWP=118.4874585019905 VSATN=77174.072210201033 VSATP=82357.294393243428 ETA0N=0.072869761324786217 ETA0P=0.07935779166735614 WS0=0.91609101269023441 WS1=0.93386738418579307 WS2=0.93966743996296231 WS3=0.9554921239688321
.alter p000178
.param VTHN=0.45355605657969211 VTHP=-0.42924442484017955 U0N=0.047260357023479596 U0P=0.01877462706653113 RDSWN=98.531618544538475 RDSWP=125.36984116192939 VSATN=72423.641685125505 VSATP=76197.206694245746 ETA0N=0.075648711596103965 ETA0P=0.086442391177065994 WS0=0.97396376922790506 WS1=1.0353798291328171 WS2=1.0943999592990079 WS3=0.95671857427375984
.alter p000179
.param VTHN=0.43760315789779686 VTHP=-0.47835085486989104 U0N=0.045435342063334973 U0P=0.021512359808283664 RDSWN=93.38514401643603 RDSWP=112.25874153460538 VSATN=83586.995777311487 VSATP=82472.792959880186 ETA0N=0.079430306103298792 ETA0P=0.078577729444542277 WS0=1.0493818370367745 WS1=1.0941860045409619 WS2=1.0870406875163057 WS3=1.0030176376244742
.alter p000180
.param VTHN=0.46224302604571349 VTHP=-0.42441363714804942 U0N=0.046111111430003689 U0P=0.01994700618700777 RDSWN=91.050422656397586 RDSWP=113.12633796207612 VSATN=75341.976786238607 VSATP=81728.56465896836 ETA0N=0.080167264779892472 ETA0P=0.083159792375534544 WS0=1.059861098193603 WS1=1.0821984295517806 WS2=0.93178848693828575 WS3=1.0894162314902001
.alter p000181
.param VTHN=0.46619724853490291 VTHP=-0.46377369467598517 U0N=0.052898948618940136 U0P=0.021757362694745718 RDSWN=92.084168378209185 RDSWP=112.61647227478562 VSATN=72907.890349415611 VSATP=81306.407559999134 ETA0N=0.072022787624669168 ETA0P=0.083435354935416317 WS0=0.95137871929708973 WS1=0.91291066550499733 WS2=0.98233268559109455 WS3=0.99225497884381098
.alter p000182
.param VTHN=0.43425208751716726 VTHP=-0.462987380997673 U0N=0.049048252496368822 U0P=0.021988298980415988 RDSWN=91.938951977473394 RDSWP=127.27932452133274 VSATN=79294.162811581875 VSATP=75729.149420692149 ETA0N=0.084143887456953434 ETA0P=0.072528198273835318 WS0=1.0919302598173923 WS1=1.0222488546680948 WS2=1.0543732137466411 WS3=1.0181245763728062
.alter p000183
.param VTHN=0.43124230950752535 VTHP=-0.46414093338593121 U0N=0.045369679584644274 U0P=0.020494009224751128 RDSWN=92.667208517035903 RDSWP=110.02661112582199 VSATN=79967.238997953507 VSATP=77920.721785133937 ETA0N=0.072063921638899006 ETA0P=0.075392225335019353 WS0=0.91058558531011824 WS1=0.94634655661187295 WS2=1.009184839858331 WS3=0.9551758164754377
.alter p000184
.param VTHN=0.47027523121917991 VTHP=-0.46359626381963642 U0N=0.052867519546147969 U0P=0.020899233491898959 RDSWN=104.35144801365058 RDSWP=117.89248762351548 VSATN=85649.720148734559 VSATP=72376.186475965194 ETA0N=0.075346945367238405 ETA0P=0.077854873628283014 WS0=0.96802553530362834 WS1=1.0432928784368556 WS2=1.070881288216744 WS3=0.95044238788393742
.alter p000185
.param VTHN=0.46071820865405089 VTHP=-0.42951089600949988 U0N=0.052611947707951544 U0P=0.020066207905870888 RDSWN=108.13929029028424 RDSWP=120.73091118595241 VSATN=75054.867995977227 VSATP=85222.030567308073 ETA0N=0.08582724351781211 ETA0P=0.084983278146194649 WS0=0.93087262364560452 WS1=1.0903205055989562 WS2=0.99804110127900292 WS3=0.95356731847953202
.alter p000186
.param VTHN=0.46740180140469606 VTHP=-0.46664884362881087 U0N=0.054337818847752364 U0P=0.020522230814974739 RDSWN=106.68896861525414 RDSWP=119.01033053342054 VSATN=72884.485188149803 VSATP=83717.412891547312 ETA0N=0.086202756410647022 ETA0P=0.080382536336362553 WS0=0.97434044802433273 WS1=0.96588156351593391 WS2=1.0332483427833168 WS3=0.95262264426292276
.alter p000187
.param VTHN=0.42967690283060223 VTHP=-0.46249022282078595 U0N=0.054414466691389558 U0P=0.019285015297974651 RDSWN=91.854757980100729 RDSWP=124.81076598549355 VSATN=87180.236618495546 VSATP=80142.731738724338 ETA0N=0.082502375160679264 ETA0P=0.084013683151003327 WS0=0.9076025459113749 WS1=0.97032370345114016 WS2=0.91510715690599775 WS3=1.0417424358784695
.alter p000188
.param VTHN=0.44528901177328711 VTHP=-0.42105432112724378 U0N=0.052189222302123986 U0P=0.020470031978849442 RDSWN=108.615692043525 RDSWP=111.65199521402404 VSATN=86148.80027699341 VSATP=75298.130697082684 ETA0N=0.084869576533311453 ETA0P=0.079594391621418376 WS0=1.0430311598387922 WS1=1.0115579199795581 WS2=0.90860633380748568 WS3=0.96783890476409884
.alter p000189
.param VTHN=0.4713377517726704 VTHP=-0.44135638571384872 U0N=0.053788256564213065 U0P=0.020254047114140767 RDSWN=94.050346416596057 RDSWP=114.16674686930925 VSATN=77611.488924496647 VSATP=77760.541222712447 ETA0N=0.081958654518663229 ETA0P=0.087193805365793062 WS0=1.0662179171867086 WS1=0.9067870293071163 WS2=0.96841771248427899 WS3=0.96824933119357104
.alter p000190
.param VTHN=0.46664992284952034 VTHP=-0.44380036167387638 U0N=0.052472798763690633 U0P=0.020719334888811537 RDSWN=105.9901382796407 RDSWP=109.30512719936691 VSATN=76392.950815301039 VSATP=74313.46349232264 ETA0N=0.074880264231028948 ETA0P=0.086805641395224467 WS0=0.97674848393432623 WS1=1.0501005493401214 WS2=1.0242289725408378 WS3=1.0510417362865909
.alter p000191
.param VTHN=0.47065999258774194 VTHP=-0.42387278111264282 U0N=0.046305432536446429 U0P=0.020454410843047392 RDSWN=90.82261252224599 RDSWP=131.83718142707207 VSATN=82255.548724621432 VSATP=85331.276576891833 ETA0N=0.079276006253175615 ETA0P=0.076745009581642792 WS0=0.91379651488896818 WS1=1.0436985921063084 WS2=1.0833817533931187 WS3=1.0292564195635707
.alter p000192
.param VTHN=0.43968716593356555 VTHP=-0.42918206177344215 U0N=0.054823486288156885 U0P=0.020442843507944126 RDSWN=107.03760664662337 RDSWP=125.79800135860314 VSATN=73809.894411605463 VSATP=73468.573671375343 ETA0N=0.081256546834124949 ETA0P=0.086984847625946007 WS0=0.95997906251410869 WS1=0.98798168757986882 WS2=0.94144472890851383 WS3=1.0117013560241195
.alter p000193
.param VTHN=0.43161096340810001 VTHP=-0.4367086533956423 U0N=0.050610594236170946 U0P=0.021494906606230227 RDSWN=97.016914755712691 RDSWP=116.23779897703973 VSATN=74795.783621657451 VSATP=82453.6915800813 ETA0N=0.084381060873874897 ETA0P=0.07875681393215396 WS0=0.96701400779733959 WS1=1.0734917181650967 WS2=0.95380416529722967 WS3=1.025632218328514
.alter p000194
.param VTHN=0.46484938649171209 VTHP=-0.47737378923671103 U0N=0.045605332275715858 U0P=0.02024473175091206 RDSWN=95.460010838756347 RDSWP=122.76522651918388 VSATN=86805.944573483197 VSATP=84162.486498349463 ETA0N=0.078634725773276709 ETA0P=0.081270165612849291 WS0=0.92475869910342956 WS1=0.96496394217125592 WS2=1.079741528331279 WS3=1.0585019129343838
.alter p000195
.param VTHN=0.42386528597271217 VTHP=-0.46074533528524497 U0N=0.047658365141519124 U0P=0.018977488899683075 RDSWN=107.70049558131296 RDSWP=119.56529590357265 VSATN=78856.358055092394 VSATP=77211.792682259169 ETA0N=0.076017038116194188 ETA0P=0.083613121611898211 WS0=1.0216889078787614 WS1=0.9983381206804558 WS2=0.93697594284561203 WS3=1.0825569700854594
.alter p000196
.param VTHN=0.44295793060353178 VTHP=-0.44185189274468351 U0N=0.047849038179525849 U0P=0.021441596751252213 RDSWN=90.861735537367579 RDSWP=127.60251761920958 VSATN=87534.9416910953 VSATP=83218.230273644906 ETA0N=0.087222622441528008 ETA0P=0.08666804033787788 WS0=1.0432907933164957 WS1=0.94777716123339906 WS2=0.96898141487818135 WS3=0.94917939126599649
.alter p000197
.param VTHN=0.45836145988733784 VTHP=-0.44233584048597008 U0N=0.051797739062309424 U0P=0.020826400760264149 RDSWN=98.112328027188894 RDSWP=117.23552832330054 VSATN=85753.86327858537 VSATP=72161.55804130972 ETA0N=0.0793701637115036 ETA0P=0.081686597376114611 WS0=0.94701152156131441 WS1=1.0127366115698979 WS2=1.0167787516667079 WS3=0.97681105415012015
.alter p000198
.param VTHN=0.47001378288285328 VTHP=-0.44895199860429186 U0N=0.048227652685226163 U0P=0.021429052732816273 RDSWN=94.211470239499747 RDSWP=108.20764165958199 VSATN=87340.727540438267 VSATP=87250.058745567498 ETA0N=0.079898275975263555 ETA0P=0.075846042098386621 WS0=1.0538374330698883 WS1=1.0997062148876195 WS2=1.0013833225759601 WS3=1.0612696939225756
.alter p000199
.param VTHN=0.42222795132318053 VTHP=-0.44329534080639238 U0N=0.045851068505621033 U0P=0.019578916895318432 RDSWN=109.66461400346569 RDSWP=120.40656723823179 VSATN=76989.764872856947 VSATP=79092.819041620329 ETA0N=0.072764509830903726 ETA0P=0.081815489473595168 WS0=0.98746887704765218 WS1=0.96866792942156477 WS2=0.94616206300482575 WS3=0.94412490200955623
.alter p000200
.param VTHN=0.47480256557537232 VTHP=-0.42898266898352899 U0N=0.048638424396658268 U0P=0.018838116822679551 RDSWN=99.678490011583989 RDSWP=128.28574226906625 VSATN=75665.662303577628 VSATP=77957.394371734947 ETA0N=0.079475792873267517 ETA0P=0.073630108365637562 WS0=0.98553480476850641 WS1=0.95817344137785676 WS2=1.0955484632039907 WS3=0.92468875385106086
.alter p000201
.param VTHN=0.43561220576485937 VTHP=-0.45126132932806851 U0N=0.050466115974637349 U0P=0.021618810016871541 RDSWN=107.9040081161847 RDSWP=129.83791755592694 VSATN=81059.624001734614 VSATP=77690.560847645262 ETA0N=0.073886216473742383 ETA0P=0.073899156525070869 WS0=0.90756290684264218 WS1=0.92569155150297067 WS2=0.90271944458177378 WS3=1.0716711727047721
.alter p000202
.param VTHN=0.46093101095993988 VTHP=-0.46032088526815323 U0N=0.052247615767533007 U0P=0.01978193356686507 RDSWN=99.547010975771485 RDSWP=129.36908920087103 VSATN=78991.086300257579 VSATP=81347.907747441946 ETA0N=0.074467943991935112 ETA0P=0.086931812434334468 WS0=1.0648092879764581 WS1=1.0243820437713531 WS2=0.9337461596940545 WS3=0.9427709613458185
.alter p000203
.param VTHN=0.46430491468298218 VTHP=-0.43858530364598003 U0N=0.053576669181407785 U0P=0.021737187684032933 RDSWN=101.67194387993237 RDSWP=108.00593830812839 VSATN=83851.462514730243 VSATP=86457.142638240039 ETA0N=0.07322546280326836 ETA0P=0.076997940823490499 WS0=0.97087088508577302 WS1=1.0633098824174827 WS2=1.0204559025207947 WS3=0.92921479482976366
.alter p000204
.param VTHN=0.46825226575271478 VTHP=-0.45088245997716192 U0N=0.047048123837085051 U0P=0.018577753469845731 RDSWN=104.4775961896348 RDSWP=127.13189000701654 VSATN=74889.481176818066 VSATP=84596.572630012219 ETA0N=0.076903837614893611 ETA0P=0.084925640652485881 WS0=0.94107984961415403 WS1=1.0016448384974876 WS2=0.93834584788340147 WS3=1.0446537173953934
.alter p000205
.param VTHN=0.43326991414399613 VTHP=-0.44281631275244193 U0N=0.048392492762360281 U0P=0.01911741632665042 RDSWN=109.02582010699703 RDSWP=115.75805840578144 VSATN=85166.510589539699 VSATP=82985.305971962196 ETA0N=0.075556374938081219 ETA0P=0.077500136751622095 WS0=1.0544970588088955 WS1=1.0846257108525532 WS2=0.92610013385995893 WS3=0.94804590332914751
.alter p000206
.param VTHN=0.43414858532005079 VTHP=-0.43444916062976979 U0N=0.045920476817990698 U0P=0.01829763481467829 RDSWN=91.898176505945017 RDSWP=108.91924762893359 VSATN=74878.410820088699 VSATP=77111.014925071082 ETA0N=0.074244258154776491 ETA0P=0.081408752343946081 WS0=1.0926061702094125 WS1=0.90911092173004326 WS2=0.93155932407903719 WS3=1.0023193702870241
.alter p000207
.param VTHN=0.46342664380089005 VTHP=-0.43345378728358785 U0N=0.050718425979234684 U0P=0.021664514109304787 RDSWN=94.782499013627287 RDSWP=122.98011471995791 VSATN=80011.660125393915 VSATP=86389.423901790724 ETA0N=0.075501076337287656 ETA0P=0.086075873622977667 WS0=1.0483042786235037 WS1=1.0870942955422169 WS2=1.0880657323008696 WS3=1.0738705582769434
.alter p000208
.param VTHN=0.42601414104392388 VTHP=-0.42181571481628127 U0N=0.049662258550577619 U0P=0.021432920975308779 RDSWN=99.118197899170298 RDSWP=123.48933820578213 VSATN=72366.314581373692 VSATP=83598.439187568845 ETA0N=0.075303192582838629 ETA0P=0.079569849258983485 WS0=0.94614670929626632 WS1=0.9556096941644372 WS2=1.0767247660721362 WS3=0.94525933308890642
.alter p000209
.param VTHN=0.46928446450980654 VTHP=-0.46786428495593302 U0N=0.046793983162852076 U0P=0.021260182865985227 RDSWN=95.400725164653068 RDSWP=131.27703888133738 VSATN=85408.726703049862 VSATP=81510.898707130793 ETA0N=0.076210105574765249 ETA0P=0.081961780933380066 WS0=1.0725132465622806 WS1=0.92193262225356831 WS2=1.0269297616619952 WS3=0.96322283631534711
.alter p000210
.param VTHN=0.47443031951114212 VTHP=-0.44871905288942171 U0N=0.045283934919486721 U0P=0.020759900384625385 RDSWN=107.76000778733253 RDSWP=128.0375686687569 VSATN=78214.936227342667 VSATP=76706.613276079137 ETA0N=0.079127058766805675 ETA0P=0.073546207425268045 WS0=1.0874200543568053 WS1=0.97615984316979898 WS2=1.000973118658194 WS3=1.0669291811300488
.alter p000211
.param VTHN=0.45452329318811707 VTHP=-0.45100257391799364 U0N=0.053533271677198388 U0P=0.020156650657547914 RDSWN=98.798497108668755 RDSWP=121.26331263648999 VSATN=86180.380336403672 VSATP=78787.882497970058 ETA0N=0.075390299520139634 ETA0P=0.073115330924263255 WS0=0.99159042958326926 WS1=1.0628957716670908 WS2=1.0426806778578026 WS3=0.99894471078777347
.alter p000212
.param VTHN=0.4679119486806475 VTHP=-0.42550994584832302 U0N=0.051327819698436875 U0P=0.01991020083873218 RDSWN=99.91207585799711 RDSWP=131.10219570598912 VSATN=80080.273484049831 VSATP=74017.75308449869 ETA0N=0.07226689870746468 ETA0P=0.08367072266505482 WS0=1.0465676964678801 WS1=1.0853053626413802 WS2=1.0431599205783872 WS3=1.0111658174484359
.alter p000213
.param VTHN=0.4292411985771602 VTHP=-0.42288086895436966 U0N=0.050252887668648993 U0P=0.018433576296525409 RDSWN=103.4459096411037 RDSWP=117.27609617821129 VSATN=81769.434130393725 VSATP=86353.580416709563 ETA0N=0.072126148352982061 ETA0P=0.078942825788296811 WS0=0.90356270895765489 WS1=0.99574442390862139 WS2=1.0867411001580423 WS3=1.0985660228163259
.alter p000214
.param VTHN=0.46067959686004706 VTHP=-0.4493813180929544 U0N=0.046148917377129201 U0P=0.019400208560440106 RDSWN=102.99872064145529 RDSWP=114.81794019023683 VSATN=81723.311722446335 VSATP=82771.261219683598 ETA0N=0.082891685326966294 ETA0P=0.077646460906133155 WS0=0.95890760056561819 WS1=1.015656815598506 WS2=0.95515262744505336 WS3=1.0015428286917216
.alter p000215
.param VTHN=0.43799757170008258 VTHP=-0.45162861420891587 U0N=0.049751116904687621 U0P=0.018355893284435567 RDSWN=98.293529528309662 RDSWP=117.20971829101698 VSATN=82612.392657890508 VSATP=83647.03017402612 ETA0N=0.082721644776144215 ETA0P=0.082613533759160182 WS0=1.024601987768254 WS1=0.91181938417673136 WS2=1.0455942812721972 WS3=0.91113256726472813
.alter p000216
.param VTHN=0.42500370459759179 VTHP=-0.4684210604701291 U0N=0.050098892528458394 U0P=0.019230708101671216 RDSWN=91.744812125049123 RDSWP=123.88462389000803 VSATN=83681.427653446182 VSATP=75077.239932860655 ETA0N=0.074395743224440605 ETA0P=0.085943140847833097 WS0=0.99677978491060248 WS1=0.90413375733760926 WS2=0.98800463574612418 WS3=1.0016860217759864
.alter p000217
.param VTHN=0.4638132902672833 VTHP=-0.43500705375995696 U0N=0.046878593373773397 U0P=0.021883584216928504 RDSWN=96.054576765179974 RDSWP=129.28868472449477 VSATN=78957.149713529652 VSATP=81061.63211591146 ETA0N=0.074797615744324045 ETA0P=0.076480091989424334 WS0=0.95828446887167795 WS1=1.0558794625045418 WS2=0.97511428777024767 WS3=0.91161439449087522
.alter p000218
.param VTHN=0.45472336558349186 VTHP=-0.44804615162586048 U0N=0.052391042286887769 U0P=0.01951696443847788 RDSWN=101.78023597149725 RDSWP=121.76250925183074 VSATN=82426.697411148984 VSATP=75549.067749351554 ETA0N=0.073036376773256029 ETA0P=0.075639610660999959 WS0=0.9877425325612601 WS1=1.041126335648765 WS2=0.94334299935904886 WS3=1.0526351133242362
.alter p000219
.param VTHN=0.46718364652900957 VTHP=-0.44693100994944401 U0N=0.053821076847822079 U0P=0.018488818627652188 RDSWN=90.439176543318553 RDSWP=109.82341202479085 VSATN=73270.891383568887 VSATP=72745.972298812252 ETA0N=0.077949127934635418 ETA0P=0.076386508335128653 WS0=1.0214939857820722 WS1=0.9348318934858878 WS2=0.93467813185581683 WS3=0.93627598940902079
.alter p000220
.param VTHN=0.45962501410085221 VTHP=-0.42875054922836764 U0N=0.052760138816351047 U0P=0.021834621894794105 RDSWN=93.22242095345689 RDSWP=129.98025638753606 VSATN=80531.890490915612 VSATP=81625.141722171116 ETA0N=0.073458320024816282 ETA0P=0.073127933473982928 WS0=0.99072233704622714 WS1=0.9054878452414008 WS2=0.97091018751015568 WS3=0.99699596859186435
.alter p000221
.param VTHN=0.46647877668721971 VTHP=-0.46101224281676123 U0N=0.046487062933267681 U0P=0.018716295853625383 RDSWN=104.39225312527574 RDSWP=111.3091854835051 VSATN=81147.210510415069 VSATP=81946.097546133053 ETA0N=0.079600027089037961 ETA0P=0.081364018711919672 WS0=1.0691778176745461 WS1=1.0287243445614065 WS2=1.0066136330383921 WS3=0.96649108654818872
.alter p000222
.param VTHN=0.45949064490415281 VTHP=-0.43613705766190908 U0N=0.045394610484154219 U0P=0.019197410789166529 RDSWN=105.53986389783925 RDSWP=110.61866870329747 VSATN=85834.417335187711 VSATP=74250.302683525704 ETA0N=0.072471833322159451 ETA0P=0.085619697182918744 WS0=1.0283181855557511 WS1=0.92008005002479887 WS2=1.0897543394428262 WS3=1.0971952310910076
.alter p000223
.param VTHN=0.47971238088392837 VTHP=-0.47484752167032579 U0N=0.048443906956395354 U0P=0.018661431894169279 RDSWN=103.65916232814718 RDSWP=127.66671380650169 VSATN=84543.135705903653 VSATP=84023.461851084357 ETA0N=0.078610089638421837 ETA0P=0.078546476498278089 WS0=0.99320114523744663 WS1=1.0248345948118889 WS2=1.0079105434804954 WS3=0.90535976368577353
.alter p000224
.param VTHN=0.45280419366745717 VTHP=-0.46484114726952286 U0N=0.054657380572736308 U0P=0.021704281167785083 RDSWN=94.56457260780509 RDSWP=121.2315892546834 VSATN=85468.142827635282 VSATP=82371.698666193275 ETA0N=0.076359355412896804 ETA0P=0.084087780164381148 WS0=1.07403329948932 WS1=0.90715821546931319 WS2=0.96095056984256355 WS3=0.95905762771882785
.alter p000225
.param VTHN=0.45059208952394109 VTHP=-0.46932190433835413 U0N=0.052046116855118132 U0P=0.020921628009048569 RDSWN=92.032305893241997 RDSWP=120.82571665916578 VSATN=73106.06104498409 VSATP=84296.8324453721 ETA0N=0.085128893766763622 ETA0P=0.08213437999605222 WS0=1.0608481214950916 WS1=0.94823834777556892 WS2=0.92810548932137193 WS3=0.93542709722838058
.alter p000226
.param VTHN=0.42248834228631532 VTHP=-0.47034712403677881 U0N=0.048576097258278016 U0P=0.020482275256760392 RDSWN=102.21149954761262 RDSWP=108.59779820064851 VSATN=87233.24724263433 VSATP=74002.794927818468 ETA0N=0.078011026049012056 ETA0P=0.073700733769423946 WS0=0.99258272117095114 WS1=0.94030901244687815 WS2=0.97594918314351764 WS3=0.98186310351465778
.alter p000227
.param VTHN=0.46553630003917484 VTHP=-0.46015110607102594 U0N=0.047801106775328193 U0P=0.020881836451109199 RDSWN=90.249235545289991 RDSWP=127.8976187500049 VSATN=79374.739022020833 VSATP=81907.390217683875 ETA0N=0.081827916232293366 ETA0P=0.075721307110561797 WS0=0.98352290883373128 WS1=0.98708230664500052 WS2=0.92946466437359521 WS3=1.061657424370843
.alter p000228
.param VTHN=0.43192083513352553 VTHP=-0.44273133268890652 U0N=0.049829334732877421 U0P=0.019784848108882556 RDSWN=108.4538325142766 RDSWP=122.24313823362256 VSATN=80596.586889428188 VSATP=79639.632217723047 ETA0N=0.0825749817998261 ETA0P=0.081307035763666727 WS0=0.94321467814589677 WS1=0.95494837505706143 WS2=1.0568170144048346 WS3=0.97268202280572813
.alter p000229
.param VTHN=0.44648594285547233 VTHP=-0.42989241235655162 U0N=0.050828253198142014 U0P=0.021067384382093296 RDSWN=93.733689723667581 RDSWP=110.96368027045803 VSATN=79839.536819315603 VSATP=75168.082264360171 ETA0N=0.076564089705321164 ETA0P=0.08064890730154485 WS0=0.9883716331403507 WS1=0.97883787970260194 WS2=0.92775957090790018 WS3=1.0646815819578193
.alter p000230
.param VTHN=0.43638380142745814 VTHP=-0.46144190624105591 U0N=0.046049160337709227 U0P=0.020359808571931856 RDSWN=94.37654184700844 RDSWP=131.14484329552556 VSATN=81582.371739502662 VSATP=73729.032637096825 ETA0N=0.086918493950278619 ETA0P=0.079971800943622606 WS0=1.0995308875663956 WS1=1.0160611990010973 WS2=1.0227125786219691 WS3=0.93384015872691661
.alter p000231
.param VTHN=0.46858324741583152 VTHP=-0.47393771172267657 U0N=0.052496037928291335 U0P=0.021874339864889725 RDSWN=102.61983962379121 RDSWP=121.33162523789117 VSATN=74166.611097472123 VSATP=73603.143116880106 ETA0N=0.075685039854227948 ETA0P=0.087201072404035726 WS0=1.0073381552445368 WS1=0.99500313529836593 WS2=1.008494090213937 WS3=1.0058802030964979
.alter p000232
.param VTHN=0.432907775448372 VTHP=-0.4518443676943466 U0N=0.054234679091580931 U0P=0.018059804684724026 RDSWN=109.94331830461654 RDSWP=120.02560587893177 VSATN=85356.461690691678 VSATP=85548.640912497402 ETA0N=0.078083373395836861 ETA0P=0.085445140704592845 WS0=0.91685841237081245 WS1=0.95302896762902356 WS2=1.0888168513473033 WS3=1.0482074355465654
.alter p000233
.param VTHN=0.45163333379632403 VTHP=-0.46987072312025863 U0N=0.048767320356787949 U0P=0.021859035313992834 RDSWN=98.873775629580464 RDSWP=115.92629595911859 VSATN=72534.00285716496 VSATP=73484.177064756164 ETA0N=0.072243282103338677 ETA0P=0.082642239097813402 WS0=0.95337077254391123 WS1=1.0345014248615432 WS2=0.96490374525947398 WS3=1.0465632461862884
.alter p000234
.param VTHN=0.46941895639631609 VTHP=-0.42570073745569703 U0N=0.045722448983087798 U0P=0.019397595605929192 RDSWN=99.718072853951497 RDSWP=127.20325208541502 VSATN=78711.523728309083 VSATP=78291.703082672364 ETA0N=0.076685166671467367 ETA0P=0.082010522082154771 WS0=1.077132182477806 WS1=1.0058466209069565 WS2=1.0228298226479076 WS3=1.0311484626025837
.alter p000235
.param VTHN=0.47649062387501001 VTHP=-0.45208218800559813 U0N=0.045498426895641333 U0P=0.018920823758197019 RDSWN=94.459550199655268 RDSWP=131.68569669123661 VSATN=81158.126942324394 VSATP=77565.665801618263 ETA0N=0.077276451327364049 ETA0P=0.076219354363376998 WS0=0.99907478151604501 WS1=1.0695991850472206 WS2=0.91974408368655747 WS3=0.90953606510269958
.alter p000236
.param VTHN=0.45535922194548484 VTHP=-0.43198970519250574 U0N=0.051425267405797073 U0P=0.020857004278407757 RDSWN=104.92489618772812 RDSWP=110.35639870058479 VSATN=85862.818458024616 VSATP=86585.839963822451 ETA0N=0.087366112279076064 ETA0P=0.07217457149919608 WS0=0.95022634147027252 WS1=0.91074630082236374 WS2=1.0135997005405675 WS3=1.008358643366317
.alter p000237
.param VTHN=0.44028459879459719 VTHP=-0.43212850087764493 U0N=0.05429262041814685 U0P=0.018349885274697324 RDSWN=105.87226696858374 RDSWP=121.60410328740092 VSATN=74049.819000057105 VSATP=86764.747183291402 ETA0N=0.078239286609085634 ETA0P=0.079452109639843727 WS0=1.0825124003450561 WS1=0.92951666711224701 WS2=0.9892418420401986 WS3=1.0720940094277105
.alter p000238
.param VTHN=0.43432703159008662 VTHP=-0.42066393682373104 U0N=0.04718640486387634 U0P=0.018856881631335476 RDSWN=102.50551300809245 RDSWP=130.9245981371453 VSATN=87127.086495323179 VSATP=74374.62657338375 ETA0N=0.083765155815071921 ETA0P=0.085409392255876126 WS0=0.97878405137213531 WS1=0.93915252488482603 WS2=0.99919835583652139 WS3=0.93733414232668633
.alter p000239
.param VTHN=0.47959682595395348 VTHP=-0.47505270430193125 U0N=0.045777966495707027 U0P=0.02018438637149848 RDSWN=91.002917921739879 RDSWP=113.75152811453975 VSATN=82807.374486021377 VSATP=87603.046278042515 ETA0N=0.083717006041837613 ETA0P=0.087161545589031469 WS0=1.0033089871914267 WS1=1.0092304772251497 WS2=0.94758532726414513 WS3=1.0299098441845054
.alter p000240
.param VTHN=0.47382668701350816 VTHP=-0.46429307005556852 U0N=0.045555480411423016 U0P=0.019590009734579771 RDSWN=92.205622426478882 RDSWP=112.57398715934599 VSATN=75889.328932249075 VSATP=73231.899746478739 ETA0N=0.075883311928560182 ETA0P=0.080592889497968709 WS0=0.93420824080583786 WS1=1.0964309775510508 WS2=1.0845335822853894 WS3=1.0132686257889476
.alter p000241
.param VTHN=0.43716188767122366 VTHP=-0.45252441378227909 U0N=0.046764244743363631 U0P=0.0181630634274851 RDSWN=107.18428916875517 RDSWP=129.0338354323961 VSATN=85693.371358355944 VSATP=75961.036585930196 ETA0N=0.08517638263616828 ETA0P=0.079877439295993141 WS0=1.020860089395917 WS1=0.99141498485091883 WS2=0.93774794308592258 WS3=0.95082676657374321
.alter p000242
.param VTHN=0.47396388433298164 VTHP=-0.47620227090864908 U0N=0.049559893571445197 U0P=0.018475968286230639 RDSWN=100.69291231151769 RDSWP=108.62524112049552 VSATN=74422.022334157824 VSATP=86516.800799416829 ETA0N=0.087771110338015684 ETA0P=0.080172938642948555 WS0=0.98471496092125788 WS1=1.0560285500861604 WS2=0.95619194571905874 WS3=0.99443761884774085
.alter p000243
.param VTHN=0.45727188471800362 VTHP=-0.469594871175883 U0N=0.053326518699955458 U0P=0.021563478387145108 RDSWN=109.62471546803702 RDSWP=126.02538339554798 VSATN=78154.851358088243 VSATP=73509.773735528986 ETA0N=0.075087351993732107 ETA0P=0.083979058249723987 WS0=0.95366212966880992 WS1=0.98974989430741733 WS2=0.9566736272431241 WS3=1.0054765615047316
.alter p000244
.param VTHN=0.46669276038266572 VTHP=-0.44638367989789629 U0N=0.053847775939853078 U0P=0.019596223471387345 RDSWN=102.58369607160058 RDSWP=126.36141149196295 VSATN=78521.549985872261 VSATP=76837.635704589818 ETA0N=0.080053848237495215 ETA0P=0.074065150667983706 WS0=0.91499131557976943 WS1=1.0143625552864122 WS2=0.94657001577818178 WS3=1.0597452633127833
.alter p000245
.param VTHN=0.47825297290859053 VTHP=-0.47958777961482474 U0N=0.047313437690134491 U0P=0.020590955160201374 RDSWN=103.28551089764473 RDSWP=121.88088289996811 VSATN=83659.375767818899 VSATP=76960.954840852442 ETA0N=0.086239591051218978 ETA0P=0.07822118396699887 WS0=0.9839102515628364 WS1=0.92908158142167996 WS2=1.0058562894024501 WS3=1.0589208990173591
.alter p000246
.param VTHN=0.42826578016336514 VTHP=-0.46690168095473777 U0N=0.050567896030525777 U0P=0.01885078829260951 RDSWN=102.3600205025144 RDSWP=110.98157762228799 VSATN=74534.346820209175 VSATP=79002.920296818134 ETA0N=0.074068659462862049 ETA0P=0.084829587674145751 WS0=0.96893209426677152 WS1=1.0642908676800513 WS2=1.0560898642634644 WS3=1.0329338937615693
.alter p000247
.param VTHN=0.42767565018792758 VTHP=-0.45048601744201866 U0N=0.051314793234997394 U0P=0.020947168266098656 RDSWN=97.429341813036046 RDSWP=127.09415533873765 VSATN=76284.374963362265 VSATP=75704.516143069428 ETA0N=0.075139220213435706 ETA0P=0.073260305785456434 WS0=0.93835346855100843 WS1=1.0863654406663166 WS2=0.98405240401611538 WS3=1.0913719392018484
.alter p000248
.param VTHN=0.47365552318013371 VTHP=-0.46311721455550531 U0N=0.047687848233549872 U0P=0.020705591627026329 RDSWN=104.41274995627148 RDSWP=120.94119868869484 VSATN=84460.271001589223 VSATP=80021.010204883234 ETA0N=0.082381172722705731 ETA0P=0.084183734120087977 WS0=1.0848569906012309 WS1=1.0565272633256526 WS2=1.0307431224976573 WS3=1.0934240008269516
.alter p000249
.param VTHN=0.46427898472388462 VTHP=-0.42001369712870518 U0N=0.049141385247995176 U0P=0.019272319395534844 RDSWN=100.65486883083766 RDSWP=111.32657971232952 VSATN=84006.424466258584 VSATP=83163.977465846474 ETA0N=0.079254289328396552 ETA0P=0.08154302537828427 WS0=0.91582885191600261 WS1=0.91819822947441632 WS2=1.0532705079030329 WS3=1.0562668689404751
.alter p000250
.param VTHN=0.46047313150213443 VTHP=-0.46264626805139497 U0N=0.046895309058343923 U0P=0.02080651211175254 RDSWN=102.76288180406718 RDSWP=112.21246066565917 VSATN=75095.88445332073 VSATP=82840.955918643056 ETA0N=0.083663837228148713 ETA0P=0.087071946456109162 WS0=1.0530494053045112 WS1=1.0301636687413294 WS2=0.98462887553197265 WS3=1.0516135281720183
.alter p000251
.param VTHN=0.47402010093430214 VTHP=-0.42020193614892509 U0N=0.048466300318085992 U0P=0.021327693559061407 RDSWN=104.57441559019114 RDSWP=112.82792179703544 VSATN=78943.480577814174 VSATP=80303.064457268483 ETA0N=0.085258455394061128 ETA0P=0.072827589413297714 WS0=1.0625556687432149 WS1=1.0688274193210261 WS2=0.93204385730907757 WS3=0.99794536786647303
.alter p000252
.param VTHN=0.46020391827375456 VTHP=-0.44561546911902028 U0N=0.05034901417143367 U0P=0.019298856286079132 RDSWN=108.27865527822979 RDSWP=126.25977141318474 VSATN=74526.101722640378 VSATP=77756.166537784549 ETA0N=0.081641897571854916 ETA0P=0.082925455890071303 WS0=1.0051848615895129 WS1=0.94165577850258009 WS2=1.08145699872526 WS3=0.96382329697408187
.alter p000253
.param VTHN=0.43150189006089668 VTHP=-0.42054354274284578 U0N=0.051953235375253905 U0P=0.018575190188974609 RDSWN=98.489240805945812 RDSWP=108.14376892524112 VSATN=86490.311152909751 VSATP=85942.296386558592 ETA0N=0.076279170181409298 ETA0P=0.083117750017792147 WS0=1.0388177125148845 WS1=1.008316582170973 WS2=0.99519590899147214 WS3=0.97543988527562087
.alter p000254
.param VTHN=0.43013114796878077 VTHP=-0.4549105495140246 U0N=0.052020959253842015 U0P=0.019573897824359546 RDSWN=103.09517655301643 RDSWP=117.15067213062008 VSATN=85085.846865455329 VSATP=85535.319082717338 ETA0N=0.081619562047299213 ETA0P=0.072065911337753488 WS0=0.99613577676639009 WS1=0.97099980943593944 WS2=1.0137169834218429 WS3=1.0957424249261916
.alter p000255
.param VTHN=0.42402733378060942 VTHP=-0.43250550241411645 U0N=0.052787574075868156 U0P=0.020288753033475812 RDSWN=105.91341057494625 RDSWP=130.36766195156574 VSATN=87734.317346267315 VSATP=87141.300320814014 ETA0N=0.087722705336946732 ETA0P=0.078421023351086472 WS0=1.0252558020470994 WS1=0.96955763166217734 WS2=0.99966291037151778 WS3=0.93401959553929403
.alter p000256
.param VTHN=0.42708067589652332 VTHP=-0.47866705135881177 U0N=0.051299853905980387 U0P=0.019102552643757785 RDSWN=100.97741996633775 RDSWP=127.71712477702445 VSATN=84488.10797537092 VSATP=84814.815785623447 ETA0N=0.080987490711563026 ETA0P=0.085343269528129845 WS0=1.0986775005375606 WS1=1.0271515018975439 WS2=1.0701977090991543 WS3=1.0067820517764665
.alter p000257
.param VTHN=0.45993873985035683 VTHP=-0.43465822764978934 U0N=0.051981972876854937 U0P=0.020723580801442685 RDSWN=103.3874067028316 RDSWP=114.53413634175703 VSATN=74037.755629682986 VSATP=79010.537742541434 ETA0N=0.085997628277640903 ETA0P=0.084736702904900235 WS0=0.98437007249621666 WS1=0.92221513632939567 WS2=1.0670745129592631 WS3=0.97353686802417072
.alter p000258
.param VTHN=0.45320919782257379 VTHP=-0.4285334405497726 U0N=0.045900059896050796 U0P=0.020874948290997716 RDSWN=107.28136480982391 RDSWP=109.59318906727286 VSATN=79071.01332675427 VSATP=79682.92033369391 ETA0N=0.077844818491215856 ETA0P=0.087381177488207618 WS0=0.92652293275554465 WS1=0.96752526738931355 WS2=1.0221162897875975 WS3=0.95796654118359392
.alter p000259
.param VTHN=0.47916322061038108 VTHP=-0.45018857580654598 U0N=0.053407154685820704 U0P=0.021253043638122995 RDSWN=101.09236362558576 RDSWP=116.93795879075519 VSATN=82733.657730664301 VSATP=76493.135905649106 ETA0N=0.074661614263962242 ETA0P=0.08347835794268095 WS0=0.94789664466145862 WS1=0.97966281122973464 WS2=1.0216518906883745 WS3=0.96019422410376598
.alter p000260
.param VTHN=0.43273427089213451 VTHP=-0.44095802481864832 U0N=0.052752047736259695 U0P=0.019024999378762474 RDSWN=104.26416706070118 RDSWP=112.31721589380729 VSATN=80239.04200062764 VSATP=78851.093511382613 ETA0N=0.075778430812605088 ETA0P=0.073208931463931384 WS0=1.0229172615822755 WS1=1.0064441635213262 WS2=1.0450946345333896 WS3=0.93853225791463313
.alter p000261
.param VTHN=0.42072211119138825 VTHP=-0.44761159150035063 U0N=0.051154047773453476 U0P=0.021797376180744836 RDSWN=93.297061695801673 RDSWP=129.60538637809151 VSATN=84614.971106038327 VSATP=74628.606075180098 ETA0N=0.081777422513638454 ETA0P=0.078681445752949358 WS0=0.96432569406530533 WS1=1.076080635637269 WS2=0.90335603362297512 WS3=0.92791894300870448
.alter p000262
.param VTHN=0.43529304844565736 VTHP=-0.42841937492181936 U0N=0.047561477621087006 U0P=0.018048942974640162 RDSWN=96.257182270193155 RDSWP=127.52364174204067 VSATN=83821.930300553606 VSATP=73648.02263127992 ETA0N=0.077089921245940149 ETA0P=0.080236617460885118 WS0=1.0783695158768376 WS1=1.0299208268871616 WS2=0.96206992692315774 WS3=0.94965298884470295
.alter p000263
.param VTHN=0.44127031770526109 VTHP=-0.47435554779389871 U0N=0.050731866602187044 U0P=0.019937712449811764 RDSWN=97.194287815147916 RDSWP=125.671154155256 VSATN=73211.249950990168 VSATP=72771.734215196993 ETA0N=0.076052675258357627 ETA0P=0.087938893077687083 WS0=1.0526044225081803 WS1=1.0677989144491797 WS2=0.90962972776711948 WS3=0.97052149085000672
.alter p000264
.param VTHN=0.42176493495554218 VTHP=-0.42421888336961683 U0N=0.054344417263256527 U0P=0.018021649062299944 RDSWN=105.21814278319759 RDSWP=108.50886644739866 VSATN=72469.199868260446 VSATP=87663.154777377422 ETA0N=0.087465570279475768 ETA0P=0.076668643415382237 WS0=1.0778750503288999 WS1=0.98082690215920521 WS2=0.90493481206345316 WS3=1.0380984776584725
.alter p000265
.param VTHN=0.47194845374584798 VTHP=-0.44165647968589056 U0N=0.046848195917230363 U0P=0.02114444934947687 RDSWN=99.567161265092935 RDSWP=131.34355647735927 VSATN=84601.933028416417 VSATP=72240.053036097088 ETA0N=0.077967003955121336 ETA0P=0.076133324586166784 WS0=0.97453730560443463 WS1=0.91035074925233417 WS2=1.0768810276654575 WS3=1.0494397440787848
.alter p000266
.param VTHN=0.47657073828601249 VTHP=-0.45108603157642141 U0N=0.046299020678527578 U0P=0.018705317195353628 RDSWN=93.689348875175838 RDSWP=118.20759121529844 VSATN=85403.241458211167 VSATP=78766.691405659585 ETA0N=0.082617335788459353 ETA0P=0.080132831463607737 WS0=0.91940542505762601 WS1=0.92286519072909723 WS2=1.0904708516465633 WS3=0.97179794358543958
.alter p000267
.param VTHN=0.43336377022696454 VTHP=-0.44392626068021063 U0N=0.046832302765077279 U0P=0.021998259191975518 RDSWN=107.48940839775941 RDSWP=119.45447400620283 VSATN=77935.903754883097 VSATP=80259.193702318589 ETA0N=0.081554766511632223 ETA0P=0.082830369982576132 WS0=1.094634243103209 WS1=0.90801363811645353 WS2=1.0418063902988031 WS3=1.0071662040772906
.alter p000268
.param VTHN=0.43139441781250748 VTHP=-0.42792652377498491 U0N=0.051651923708906471 U0P=0.018606494026516825 RDSWN=100.94609024223391 RDSWP=124.7173818210388 VSATN=81103.647795988072 VSATP=72593.890171494626 ETA0N=0.074548718907049935 ETA0P=0.074016668506651048 WS0=1.0904635750791325 WS1=0.94542827623612635 WS2=1.0996254052820427 WS3=1.0977858002497645
.alter p000269
.param VTHN=0.4587928659975779 VTHP=-0.46751172419086773 U0N=0.049320593302172352 U0P=0.020305033846626727 RDSWN=109.16488068646265 RDSWP=110.09604309425146 VSATN=72773.423449692724 VSATP=77159.683736736464 ETA0N=0.076613483882332828 ETA0P=0.073292486403262413 WS0=1.058636139467668 WS1=1.0914018139783923 WS2=0.95772447973781227 WS3=1.0991962424897093
.alter p000270
.param VTHN=0.46447445677464605 VTHP=-0.45272520746541056 U0N=0.052539120239268156 U0P=0.019373326759536527 RDSWN=103.84273988587101 RDSWP=120.52404085897372 VSATN=86747.711651944119 VSATP=79979.956383092125 ETA0N=0.073806930654031114 ETA0P=0.086895610280792762 WS0=1.0041352206464591 WS1=1.0282743552008955 WS2=1.0736602761367307 WS3=0.93977157212609908
.alter p000271
.param VTHN=0.45026855018960454 VTHP=-0.45708881705369114 U0N=0.045271905316583226 U0P=0.019164338601381711 RDSWN=91.680533550828187 RDSWP=108.16818833409232 VSATN=74195.476365285402 VSATP=80990.671190623267 ETA0N=0.087326309309019315 ETA0P=0.079299624494783671 WS0=0.97574524925331008 WS1=1.0791677224556688 WS2=0.93943044042475521 WS3=1.0102421874663894
.alter p000272
.param VTHN=0.46457250928399779 VTHP=-0.43860921192302621 U0N=0.049968114843305309 U0P=0.018195055321296335 RDSWN=92.795481541857384 RDSWP=111.18137051018383 VSATN=77864.953462861391 VSATP=72019.580623435628 ETA0N=0.079974126468923587 ETA0P=0.081831726143437186 WS0=1.0846759405782853 WS1=1.0444364964479183 WS2=0.92988680200735474 WS3=1.0964506932810618
.alter p000273
.param VTHN=0.43472500125906544 VTHP=-0.46491498584016688 U0N=0.047948322676502605 U0P=0.021052730690065358 RDSWN=101.8784146417366 RDSWP=127.83482285830998 VSATN=77124.80787132906 VSATP=79376.294796810718 ETA0N=0.080479066503982594 ETA0P=0.082161923230367695 WS0=1.0982412454777084 WS1=1.0970793114236466 WS2=0.99854099929429829 WS3=0.95836866926127739
.alter p000274
.param VTHN=0.45890873715099589 VTHP=-0.42753609096337486 U0N=0.054881125204438101 U0P=0.021544953783820726 RDSWN=97.294077125338191 RDSWP=119.66247366074565 VSATN=78376.546038562359 VSATP=79352.479289624156 ETA0N=0.078788019195823497 ETA0P=0.085236051602529117 WS0=1.0757216786490829 WS1=0.92523930667318077 WS2=1.0329786098296263 WS3=0.97676549703970061
.alter p000275
.param VTHN=0.45756918836803234 VTHP=-0.46627009884217707 U0N=0.051672790150339168 U0P=0.020811356174080777 RDSWN=97.106734044746105 RDSWP=118.76608102033182 VSATN=72172.536114937742 VSATP=77013.514736515484 ETA0N=0.075050466966427615 ETA0P=0.082284568008995057 WS0=0.99318155548317577 WS1=1.0469931423670171 WS2=0.99435851051234525 WS3=0.93655854539386341
.alter p000276
.param VTHN=0.45735882956977703 VTHP=-0.43244763611443116 U0N=0.051584190236174346 U0P=0.020627156772906965 RDSWN=106.18323502574093 RDSWP=116.45030763135733 VSATN=77438.707424076638 VSATP=87426.144891352058 ETA0N=0.084906815727578105 ETA0P=0.084102932289709872 WS0=0.98889097767493095 WS1=1.0848924728631848 WS2=0.9908338591069219 WS3=1.0771548099432795
.alter p000277
.param VTHN=0.44785515736245873 VTHP=-0.47196846645784618 U0N=0.050426371482779786 U0P=0.021244392274340516 RDSWN=100.00511658320727 RDSWP=129.19045867933318 VSATN=79993.6634714955 VSATP=87220.460754715226 ETA0N=0.0839676806637083 ETA0P=0.087615843881628561 WS0=1.0097474131235793 WS1=1.0785847079251656 WS2=1.0107029598516155 WS3=0.94639699019059065
.alter p000278
.param VTHN=0.43902114004538922 VTHP=-0.46722424495797138 U0N=0.045813438376077674 U0P=0.018609608621106874 RDSWN=94.647451603808292 RDSWP=130.94570876722034 VSATN=73297.532070421221 VSATP=85759.951558280052 ETA0N=0.087509686486533983 ETA0P=0.07926039452641144 WS0=0.96980206284287018 WS1=0.954668919187176 WS2=1.0278197081309963 WS3=0.90973108008658898
.alter p000279
.param VTHN=0.44869774108829574 VTHP=-0.42623504696698633 U0N=0.05475759106982668 U0P=0.020472971081154766 RDSWN=95.77093682198074 RDSWP=122.44625971128696 VSATN=75140.401482248941 VSATP=86087.169536501155 ETA0N=0.07968939910203629 ETA0P=0.077718246174907274 WS0=0.97899513221373147 WS1=1.0486496490899295 WS2=0.90148118671998234 WS3=0.99377104587234277
.alter p000280
.param VTHN=0.45612601964087318 VTHP=-0.45632825886890194 U0N=0.05411368965564857 U0P=0.018292550393981932 RDSWN=97.078915460826465 RDSWP=122.88562807967661 VSATN=76344.66350409048 VSATP=80220.758580188267 ETA0N=0.083540616967543863 ETA0P=0.075188900952128115 WS0=0.97170223033436776 WS1=0.90592963558491835 WS2=1.0632810619221726 WS3=1.0549332765815502
.alter p000281
.param VTHN=0.43250961538773658 VTHP=-0.46914904495469922 U0N=0.050070351692622292 U0P=0.020060576481649991 RDSWN=92.176599306106567 RDSWP=113.27454506951121 VSATN=83391.582128637368 VSATP=73852.355096958272 ETA0N=0.087071503457495147 ETA0P=0.079693761085879514 WS0=1.0168202265549082 WS1=0.91680274119811977 WS2=1.0092398541588452 WS3=1.0639164850364597
.alter p000282
.param VTHN=0.44506593250591614 VTHP=-0.45420704534361267 U0N=0.048688241144404232 U0P=0.019235783427066749 RDSWN=98.643748706869943 RDSWP=130.73442770502132 VSATN=75499.057588121039 VSATP=78585.443717213857 ETA0N=0.087844685237017689 ETA0P=0.073928661456213421 WS0=0.92633533805152368 WS1=1.0888606171171633 WS2=0.92427124384566728 WS3=1.0413415641349286
.alter p000283
.param VTHN=0.47048477916655967 VTHP=-0.42531875868425761 U0N=0.052640133714379589 U0P=0.018209133203097878 RDSWN=102.46268021238765 RDSWP=128.24022796772837 VSATN=86074.106044348053 VSATP=75344.926604549939 ETA0N=0.077236638892534931 ETA0P=0.074714851013700442 WS0=1.0335795708680326 WS1=1.0233883655707561 WS2=0.95731780728064597 WS3=1.0607948830293494
.alter p000284
.param VTHN=0.45653763271116188 VTHP=-0.44841303317096626 U0N=0.052974259579922918 U0P=0.019847262473738393 RDSWN=99.738858390886449 RDSWP=119.90063205892774 VSATN=72086.917237224246 VSATP=76533.477085883758 ETA0N=0.082086278710932756 ETA0P=0.08621248683645702 WS0=0.94169218103535179 WS1=0.94919441045930386 WS2=0.96606326785033025 WS3=0.92013950061455196
.alter p000285
.param VTHN=0.43888773417168853 VTHP=-0.45778181435368942 U0N=0.048419909056341526 U0P=0.021132585461009649 RDSWN=94.124028009282412 RDSWP=122.33643794787783 VSATN=83969.117569137277 VSATP=84875.850597304932 ETA0N=0.075907347351079152 ETA0P=0.077408035188782615 WS0=1.0133288207841507 WS1=1.0988418359210872 WS2=1.0341304524431494 WS3=0.93935171814999363
.alter p000286
.param VTHN=0.4373108645120759 VTHP=-0.43847968156140193 U0N=0.047524641611103022 U0P=0.020323920431503231 RDSWN=94.998370755459007 RDSWP=121.48832458503051 VSATN=72694.138918160606 VSATP=72476.976150817791 ETA0N=0.077201950873120373 ETA0P=0.082055126151101984 WS0=0.95682114253779593 WS1=0.90856936302007241 WS2=1.0017984197118552 WS3=0.93265999926245258
.alter p000287
.param VTHN=0.47203043165291014 VTHP=-0.42304372378695332 U0N=0.045167385032366794 U0P=0.02123459573380046 RDSWN=99.294027228596462 RDSWP=120.61838069657286 VSATN=72660.426734958935 VSATP=80574.448572882859 ETA0N=0.08325309634680883 ETA0P=0.073370939577123845 WS0=1.0203534665927443 WS1=0.92376536137199061 WS2=1.0436670914057793 WS3=1.026857280971504
.alter p000288
.param VTHN=0.45859307155163753 VTHP=-0.45556750558781822 U0N=0.054920176503483346 U0P=0.021680338789394057 RDSWN=93.109882017308493 RDSWP=117.00700515192997 VSATN=76686.803430478249 VSATP=78123.624497007142 ETA0N=0.074692446274860227 ETA0P=0.079121253153442928 WS0=0.90708967764554627 WS1=1.0102901789329235 WS2=1.0485178133853255 WS3=0.91853197311333035
.alter p000289
.param VTHN=0.46908013617220379 VTHP=-0.4314429717646765 U0N=0.045790321999090347 U0P=0.019491367035073263 RDSWN=104.29080659934947 RDSWP=112.37002203245463 VSATN=78039.943250797311 VSATP=86140.189658027739 ETA0N=0.079630386164235178 ETA0P=0.074200329511328766 WS0=1.0941914994564692 WS1=1.0521770782243478 WS2=1.0750232276128848 WS3=0.90351320304755445
.alter p000290
.param VTHN=0.43171321963881615 VTHP=-0.43665514421858398 U0N=0.04884783648966004 U0P=0.021935886492098024 RDSWN=91.553879067425569 RDSWP=129.50454181602396 VSATN=77757.418529583796 VSATP=79303.035420112574 ETA0N=0.081673451053873858 ETA0P=0.08487904911339221 WS0=0.95109128648765129 WS1=1.0039437799689002 WS2=0.9231206585881645 WS3=0.96556953612579688
.alter p000291
.param VTHN=0.43588510993079987 VTHP=-0.47242268058242909 U0N=0.053026621055642535 U0P=0.019481659448274475 RDSWN=107.08287624610431 RDSWP=117.43268838110072 VSATN=84913.417310336386 VSATP=83983.033135901438 ETA0N=0.082162942732039723 ETA0P=0.077896982231580689 WS0=0.96187212184585758 WS1=1.0226883727173803 WS2=0.94836344170084308 WS3=0.99337657646890398
.alter p000292
.param VTHN=0.44041070475455213 VTHP=-0.46448526533207612 U0N=0.053173594141571218 U0P=0.02000234757294524 RDSWN=97.121495020765522 RDSWP=131.63828181252109 VSATN=78780.697497576984 VSATP=84211.087141365366 ETA0N=0.08431171623492216 ETA0P=0.074421084173120544 WS0=1.0367839509443355 WS1=0.9381987461306931 WS2=1.0500394683051113 WS3=1.0629438688059669
.alter p000293
.param VTHN=0.43086677274692264 VTHP=-0.43283068781478012 U0N=0.048805896840233336 U0P=0.018093352732079723 RDSWN=97.952739160949577 RDSWP=131.45029547218226 VSATN=83409.103618700145 VSATP=75495.384532417171 ETA0N=0.086857373441506291 ETA0P=0.08675152662207565 WS0=1.0523585250864427 WS1=0.98821451412497274 WS2=0.98905278466444102 WS3=1.0917897221740094
.alter p000294
.param VTHN=0.45223295564075233 VTHP=-0.44209959577649777 U0N=0.049102332435377809 U0P=0.020867527503045359 RDSWN=99.074575335612224 RDSWP=125.83424455216658 VSATN=75644.222656019148 VSATP=82612.465003553603 ETA0N=0.075866839946363562 ETA0P=0.080922370285095011 WS0=0.96556544782697773 WS1=0.95387355449300493 WS2=0.97905625040013877 WS3=0.92054980905817241
.alter p000295
.param VTHN=0.42888326055710885 VTHP=-0.46888856233648252 U0N=0.053894620183528218 U0P=0.018451278658643672 RDSWN=90.074667041729015 RDSWP=130.08280267243731 VSATN=75363.665184287864 VSATP=78962.507543248692 ETA0N=0.072945095311610322 ETA0P=0.077461561706914997 WS0=1.037708688356257 WS1=0.98327602854117924 WS2=0.93086248911221547 WS3=1.0772978586540025
.alter p000296
.param VTHN=0.44219548317176838 VTHP=-0.47087583328894544 U0N=0.051804489966441165 U0P=0.019038103144106835 RDSWN=109.41984932447387 RDSWP=129.71747490343563 VSATN=79301.806191658878 VSATP=84438.03445972949 ETA0N=0.073969672977988954 ETA0P=0.080257620905615557 WS0=0.99730050083341348 WS1=1.0051426145319755 WS2=1.0253749364070055 WS3=0.94583518294099922
.alter p000297
.param VTHN=0.47117039852519732 VTHP=-0.4536251085681367 U0N=0.054784750667499299 U0P=0.019250395266418464 RDSWN=101.13989283074338 RDSWP=117.56040757802238 VSATN=75571.521465994709 VSATP=74549.597036979016 ETA0N=0.087980243974092348 ETA0P=0.077680496301678587 WS0=0.91914460549709931 WS1=1.0947142886454815 WS2=0.9807208011025621 WS3=0.99606727900131553
.alter p000298
.param VTHN=0.43740345734970298 VTHP=-0.42208378251457163 U0N=0.047456643002084367 U0P=0.018031028328056361 RDSWN=106.66290204521329 RDSWP=112.65867040055325 VSATN=75305.565948457355 VSATP=85589.20056325238 ETA0N=0.081466235860997313 ETA0P=0.08289820656983149 WS0=1.0763806878151421 WS1=0.93099379496623835 WS2=0.96793298494927038 WS3=1.0360500657738698
.alter p000299
.param VTHN=0.42647589540935954 VTHP=-0.47260571665615281 U0N=0.053744175637982221 U0P=0.018878423018194933 RDSWN=92.589904039726932 RDSWP=123.56727490485507 VSATN=77821.392849042939 VSATP=72111.280727065634 ETA0N=0.079737263178721179 ETA0P=0.079750178022470183 WS0=0.90269594185639279 WS1=1.0696994554271684 WS2=1.0820072256335913 WS3=0.9573313306857747
.alter p000300
.param VTHN=0.43598184315409588 VTHP=-0.42906723919736112 U0N=0.054998957094397762 U0P=0.02034329190002521 RDSWN=109.89494274278309 RDSWP=121.55090252673335 VSATN=72605.080776988325 VSATP=72285.45118457239 ETA0N=0.083387760938179553 ETA0P=0.074882182340064191 WS0=1.0193596342744744 WS1=1.0782595175501919 WS2=0.9351413417707003 WS3=0.97745735909750298
.alter p000301
.param VTHN=0.47290779731683297 VTHP=-0.44954143367330696 U0N=0.045898082712383124 U0P=0.01837451116936541 RDSWN=105.02285124286414 RDSWP=125.26861251695451 VSATN=87975.676632400078 VSATP=81252.935977389046 ETA0N=0.073091242273452331 ETA0P=0.076259579555092313 WS0=1.0249577209000624 WS1=0.96995387491697527 WS2=1.0673669567125235 WS3=0.92594414531154834
.alter p000302
.param VTHN=0.47592200319949174 VTHP=-0.45000551786843873 U0N=0.047438349841172046 U0P=0.018598160484349865 RDSWN=104.65017348244425 RDSWP=129.33272104538881 VSATN=76578.301612063791 VSATP=78109.446052697123 ETA0N=0.0827141533742205 ETA0P=0.078732382847722479 WS0=0.92084781189491927 WS1=1.0155575535716888 WS2=0.97696161078781873 WS3=0.97820321542949906
.alter p000303
.param VTHN=0.43995051301376631 VTHP=-0.45597456950098841 U0N=0.052328131876329773 U0P=0.018441820871241847 RDSWN=102.70884334341822 RDSWP=120.62953053166139 VSATN=86911.657580323081 VSATP=86540.311255398759 ETA0N=0.086585790658865236 ETA0P=0.072787805460019353 WS0=1.0059582945061112 WS1=0.90191514867554357 WS2=1.0829103010140728 WS3=1.0365110834625648
.alter p000304
.param VTHN=0.4509955359190298 VTHP=-0.4685326401431093 U0N=0.047204881484590094 U0P=0.019869773025770497 RDSWN=101.38324923728067 RDSWP=130.41190593134397 VSATN=84836.046443153726 VSATP=77310.258689004986 ETA0N=0.077877309095561856 ETA0P=0.085213873239082305 WS0=1.0191263527457586 WS1=1.0026074854540377 WS2=1.0288608897828513 WS3=0.94179085923321415
.alter p000305
.param VTHN=0.44880856597059993 VTHP=-0.42637078804404155 U0N=0.052208647371752619 U0P=0.02181646751810248 RDSWN=108.82589307676545 RDSWP=119.84976949882639 VSATN=76186.740538979124 VSATP=82150.065014950465 ETA0N=0.075455032344886389 ETA0P=0.083797744615534561 WS0=0.93042945879647765 WS1=0.96187377384798189 WS2=1.0984051182926864 WS3=0.97107930229769246
.alter p000306
.param VTHN=0.44508770145337834 VTHP=-0.42362022593546972 U0N=0.047122285570326439 U0P=0.01884159503917749 RDSWN=95.12375179825159 RDSWP=131.59241354742861 VSATN=84237.902120320359 VSATP=77263.745667937037 ETA0N=0.075247507564002211 ETA0P=0.07268441562983198 WS0=0.91994824365735151 WS1=0.98025986022361933 WS2=1.0536832113980139 WS3=1.0275405278938332
.alter p000307
.param VTHN=0.42416705629227602 VTHP=-0.42376350792381079 U0N=0.053217973581774505 U0P=0.021983437504311691 RDSWN=100.81290163937622 RDSWP=126.44653662565918 VSATN=83050.103897445151 VSATP=79649.01676083832 ETA0N=0.083557554875663506 ETA0P=0.083874393653470422 WS0=0.93264950138201985 WS1=0.90773492565772773 WS2=1.0160547351886466 WS3=0.96095945423639584
.alter p000308
.param VTHN=0.43690132495676376 VTHP=-0.4309455146407884 U0N=0.054188002780746133 U0P=0.020983070873694255 RDSWN=107.57784528481352 RDSWP=109.23162253220517 VSATN=86636.478358516091 VSATP=81003.480025147946 ETA0N=0.079792471308679253 ETA0P=0.085539188817577577 WS0=1.0026870500052214 WS1=1.0180558200117793 WS2=1.033761172497772 WS3=0.9062672878869189
.alter p000309
.param VTHN=0.43651307938248102 VTHP=-0.47061639336621119 U0N=0.050044535885157226 U0P=0.019634055296712988 RDSWN=103.68277573713222 RDSWP=124.37324655626229 VSATN=83140.886910199028 VSATP=82081.918620259356 ETA0N=0.08675954907604716 ETA0P=0.080686027523771908 WS0=0.92423999611310725 WS1=0.98385506381691157 WS2=1.0684775729886522 WS3=0.97476360305099763
.alter p000310
.param VTHN=0.43981357040070895 VTHP=-0.42132818653131515 U0N=0.04990783219010976 U0P=0.021345001550883893 RDSWN=100.5309151831155 RDSWP=110.48806673975899 VSATN=87155.913908718619 VSATP=75675.222292534803 ETA0N=0.078971211161907071 ETA0P=0.075896416431928224 WS0=1.0397194484633561 WS1=0.90627718990889605 WS2=0.927295907805329 WS3=1.0350300405733512
.alter p000311
.param VTHN=0.43852750128546203 VTHP=-0.47465087826463287 U0N=0.04902848016871323 U0P=0.019770715855182835 RDSWN=98.63414640931974 RDSWP=124.69568496855962 VSATN=75684.630719080247 VSATP=86936.226157515252 ETA0N=0.081233862265040702 ETA0P=0.08502895685021622 WS0=0.90002260049817395 WS1=1.0801137976858577 WS2=0.91464521021753342 WS3=1.0528285529345851
.alter p000312
.param VTHN=0.43670705190033637 VTHP=-0.43202096181175842 U0N=0.050742622720970604 U0P=0.018104213062928694 RDSWN=98.709518368292052 RDSWP=126.90332095302415 VSATN=72387.742365019731 VSATP=74493.548113924626 ETA0N=0.083458058901142967 ETA0P=0.081944284873456924 WS0=0.99479903372273104 WS1=1.0015690796289942 WS2=0.91801630035796644 WS3=0.92254004158871072
.alter p000313
.param VTHN=0.43375325993964825 VTHP=-0.46007361376128991 U0N=0.052704227503451176 U0P=0.021116126733015501 RDSWN=106.82016491658526 RDSWP=111.61889833264749 VSATN=82099.497766791595 VSATP=78228.46865707876 ETA0N=0.087174942361600768 ETA0P=0.078172938749499848 WS0=0.9376861850193513 WS1=0.96028136986970281 WS2=0.9358914380593385 WS3=1.0656159219516788
.alter p000314
.param VTHN=0.44592344875163287 VTHP=-0.4202445869448887 U0N=0.05208245814443685 U0P=0.019146831803579289 RDSWN=104.87155037148344 RDSWP=128.11232689215083 VSATN=78590.189106116057 VSATP=80045.771471918706 ETA0N=0.079834570787976261 ETA0P=0.077519255131170736 WS0=0.94512601422384512 WS1=1.0736297726407891 WS2=0.94891025268470697 WS3=1.0688333765771372
.alter p000315
.param VTHN=0.44266119681512417 VTHP=-0.42246511938612286 U0N=0.054300690598393805 U0P=0.021100638815748668 RDSWN=92.895561751291353 RDSWP=118.12394552299695 VSATN=82647.028831546922 VSATP=76605.505137540633 ETA0N=0.078725442920321645 ETA0P=0.085911177571112787 WS0=0.96110492882881282 WS1=1.0608449236981887 WS2=1.0779600600530677 WS3=1.0594936944307249
.alter p000316
.param VTHN=0.47978887819171867 VTHP=-0.42236103234979228 U0N=0.047760857373107236 U0P=0.019995954352509473 RDSWN=97.965873758783019 RDSWP=114.5215755438787 VSATN=78911.705797536735 VSATP=76546.916366176563 ETA0N=0.085297922651499075 ETA0P=0.074436277631104761 WS0=1.0595818221532145 WS1=1.0343026399761861 WS2=1.0142566398356836 WS3=1.0410679205907925
.alter p000317
.param VTHN=0.42319260423585225 VTHP=-0.42111865902733281 U0N=0.048186160246212952 U0P=0.020818419157208279 RDSWN=97.250291476103357 RDSWP=116.7910287475905 VSATN=77528.616196866831 VSATP=80901.922195894251 ETA0N=0.083310859282512695 ETA0P=0.086279819085638712 WS0=1.0814995074645066 WS1=1.0402902560807203 WS2=1.0976675400823657 WS3=0.95370144223434605
.alter p000318
.param VTHN=0.46882714491581129 VTHP=-0.45690662282294559 U0N=0.052273729108527206 U0P=0.019703113057273153 RDSWN=109.27754807836283 RDSWP=128.9247501723832 VSATN=76645.258927087765 VSATP=74964.723352516099 ETA0N=0.078295199077389036 ETA0P=0.080394730252144345 WS0=0.91038178454486962 WS1=0.95330945743014373 WS2=1.030307612964555 WS3=1.0522014400349451
.alter p000319
.param VTHN=0.42370980745966275 VTHP=-0.4592976862946696 U0N=0.049721428135456783 U0P=0.019107609013604282 RDSWN=107.72859673399977 RDSWP=124.55543119519155 VSATN=80993.932270281875 VSATP=72842.439308679255 ETA0N=0.072498904014521984 ETA0P=0.077870526343044491 WS0=0.91284295815028527 WS1=0.94597530976952149 WS2=1.0637843571921015 WS3=0.99123707992835319
.alter p000320
.param VTHN=0.46734640082818846 VTHP=-0.42709307016365711 U0N=0.048702290991747089 U0P=0.01920327628725749 RDSWN=107.62397643883348 RDSWP=109.10635600894382 VSATN=77586.692528943342 VSATP=77373.859197129947 ETA0N=0.086418116361418981 ETA0P=0.081661282405316782 WS0=1.0572432722677896 WS1=0.90329060095041813 WS2=1.0676579706937834 WS3=0.91054314653826662
.alter p000321
.param VTHN=0.45565629948347125 VTHP=-0.46345139428595977 U0N=0.053955290516443828 U0P=0.019327927474295278 RDSWN=96.791333905448809 RDSWP=126.78321475642849 VSATN=85724.517687835862 VSATP=87804.760438597179 ETA0N=0.086904487546745415 ETA0P=0.076418195739300754 WS0=1.009061635601521 WS1=1.0193777257102248 WS2=1.0312520961293006 WS3=1.0840200384626066
.alter p000322
.param VTHN=0.44424078014394852 VTHP=-0.43985427923263992 U0N=0.051206459198419957 U0P=0.019549750902395194 RDSWN=93.486103240996925 RDSWP=110.19726553082786 VSATN=72207.581646597988 VSATP=80653.066396163398 ETA0N=0.083004090168713573 ETA0P=0.079714049871515966 WS0=0.92160209692601436 WS1=0.96826943732902282 WS2=1.0948411936101359 WS3=1.0948782584286871
.alter p000323
.param VTHN=0.43833499684373683 VTHP=-0.46558695180065401 U0N=0.054136905891778497 U0P=0.019754220243858211 RDSWN=105.95436589173448 RDSWP=116.09891140084557 VSATN=84292.161691488407 VSATP=82252.127220962779 ETA0N=0.074426714073782263 ETA0P=0.081209135613939179 WS0=1.0363939733187519 WS1=1.0644198075199414 WS2=0.90069055961937694 WS3=0.95229269688276874
.alter p000324
.param VTHN=0.47088693656412101 VTHP=-0.43718594636917024 U0N=0.046915071051870899 U0P=0.021218966525045714 RDSWN=100.40837838847948 RDSWP=120.18814879046863 VSATN=81415.323214905948 VSATP=87729.200473836579 ETA0N=0.086824880563983589 ETA0P=0.081388052824705334 WS0=1.0267187191857652 WS1=1.0334685197369564 WS2=0.98024165859213597 WS3=1.0175626212994688
.alter p000325
.param VTHN=0.46266014361785363 VTHP=-0.46023811985021273 U0N=0.047256251278082133 U0P=0.020597050112275507 RDSWN=105.1696835150838 RDSWP=116.35619362930383 VSATN=73659.570046685083 VSATP=82064.25235522748 ETA0N=0.076822451418472756 ETA0P=0.073324143541519171 WS0=1.048968439480304 WS1=1.0619097620715736 WS2=1.0003321325996322 WS3=0.9619796651367345
.alter p000326
.param VTHN=0.47038735451167957 VTHP=-0.42275946494890632 U0N=0.051702618007456319 U0P=0.019731582531512359 RDSWN=106.73842049441532 RDSWP=112.9169909442123 VSATN=75115.123794621133 VSATP=85903.027368037598 ETA0N=0.087793965700152937 ETA0P=0.086586203854907812 WS0=0.95306902052229736 WS1=1.0919146124000527 WS2=1.0052888441214449 WS3=1.0244398434840549
.alter p000327
.param VTHN=0.46593454381432764 VTHP=-0.46977701633290603 U0N=0.052562081866891271 U0P=0.018685420013993211 RDSWN=108.38232888425431 RDSWP=112.06055209539606 VSATN=86044.02457204205 VSATP=78613.11968380383 ETA0N=0.080834149639860214 ETA0P=0.084690963281773418 WS0=0.95746185778566884 WS1=0.90214019958161462 WS2=0.95847416537954777 WS3=1.0503272630345402
.alter p000328
.param VTHN=0.45502041938160226 VTHP=-0.46571700642489999 U0N=0.045535776849843598 U0P=0.019209171604877631 RDSWN=98.833144235941674 RDSWP=113.99473356303315 VSATN=81189.932811344013 VSATP=83856.364922068416 ETA0N=0.085096202768722734 ETA0P=0.080211294149168236 WS0=0.94305013849338426 WS1=1.0055342867984802 WS2=1.0398627659867878 WS3=0.92906892288178733
.alter p000329
.param VTHN=0.47854026557361584 VTHP=-0.4690683238017066 U0N=0.047172238286473517 U0P=0.018815267421756248 RDSWN=106.85072794835142 RDSWP=111.13098494298286 VSATN=74295.48313108545 VSATP=85793.714740649229 ETA0N=0.080298948755317442 ETA0P=0.075828711587786271 WS0=0.9143371222006591 WS1=1.0684049603060819 WS2=0.90101090465624811 WS3=0.97236488377763342
.alter p000330
.param VTHN=0.44700664368457049 VTHP=-0.46388616847081776 U0N=0.054700355521659819 U0P=0.021359251258734092 RDSWN=103.07122845138306 RDSWP=112.73423082586581 VSATN=73168.53058005964 VSATP=82233.768333639178 ETA0N=0.075970974708386277 ETA0P=0.082387838511181963 WS0=1.0932221430643594 WS1=1.0959559127394509 WS2=0.96337057085999434 WS3=1.0368829834878013
.alter p000331
.param VTHN=0.42354657950239527 VTHP=-0.43361230475175921 U0N=0.04867566155356471 U0P=0.020557145747008874 RDSWN=102.11765151525316 RDSWP=111.55154126318786 VSATN=80305.869127595943 VSATP=86179.580765123712 ETA0N=0.074088528258476255 ETA0P=0.076092348510257007 WS0=0.9122919447697021 WS1=0.9421058124169055 WS2=1.0021731664710576 WS3=0.99745332537474751
.alter p000332
.param VTHN=0.46564210233882786 VTHP=-0.42222958792468351 U0N=0.050392737974400477 U0P=0.02011864499153302 RDSWN=105.67929894457318 RDSWP=114.25359974775313 VSATN=85245.762094271515 VSATP=75391.015086388754 ETA0N=0.086951261877460995 ETA0P=0.073788867071872363 WS0=0.96056138031848248 WS1=0.93239370769725183 WS2=0.93533295732086441 WS3=0.96268414797912283
.alter p000333
.param VTHN=0.466305913361443 VTHP=-0.44467654215237651 U0N=0.050635696829350804 U0P=0.021190011086471304 RDSWN=91.103273265327971 RDSWP=130.85093529169617 VSATN=83274.053421143835 VSATP=81231.129161013552 ETA0N=0.083064349741884272 ETA0P=0.08638034081575964 WS0=0.96857402722948605 WS1=0.92750349948133726 WS2=1.0966725706980838 WS3=0.97423878555308796
.alter p000334
.param VTHN=0.4519789678779107 VTHP=-0.42521253193608088 U0N=0.051348386010967521 U0P=0.018151367915272287 RDSWN=107.33765760130782 RDSWP=128.65008433403418 VSATN=86878.188703830936 VSATP=81880.739091522526 ETA0N=0.074437209045386671 ETA0P=0.080459100920134405 WS0=1.0346957091013318 WS1=0.99950801642074172 WS2=1.0042155450888364 WS3=1.0073566427876874
.alter p000335
.param VTHN=0.42033239000075517 VTHP=-0.42560138943354192 U0N=0.051627769010781567 U0P=0.020182805304302758 RDSWN=93.178910978090101 RDSWP=130.15253192003232 VSATN=85605.479517432308 VSATP=79156.880402404364 ETA0N=0.0769660898698135 ETA0P=0.087410273501433031 WS0=1.0453431313486456 WS1=0.99651326056531431 WS2=1.0683633113082767 WS3=0.97858688323417231
.alter p000336
.param VTHN=0.46188794206977879 VTHP=-0.47131369162021131 U0N=0.050979106313936234 U0P=0.019424804209497118 RDSWN=97.745664246368065 RDSWP=113.44332888739397 VSATN=78182.824170450738 VSATP=74165.364312186459 ETA0N=0.086173648796845151 ETA0P=0.081469446235595169 WS0=1.0605142490152433 WS1=1.0091251809907587 WS2=1.0365550782931159 WS3=1.0286853382265206
.alter p000337
.param VTHN=0.44797282390305693 VTHP=-0.42043783334279833 U0N=0.049863612876989413 U0P=0.018393216479707087 RDSWN=92.486720916616392 RDSWP=123.25298540805593 VSATN=84545.269903164794 VSATP=77999.500576950886 ETA0N=0.072627485940357714 ETA0P=0.084561947649224936 WS0=0.9956923316565196 WS1=0.90148634346096157 WS2=0.97260255926143335 WS3=0.99077087913946416
.alter p000338
.param VTHN=0.44968791211570547 VTHP=-0.43742550447497874 U0N=0.04957432203047063 U0P=0.018116766798060586 RDSWN=99.455687537950425 RDSWP=116.70886649633657 VSATN=86278.978259553071 VSATP=83958.688127567861 ETA0N=0.080632302766550618 ETA0P=0.078697868507942179 WS0=0.97536208389838153 WS1=1.0111101376262457 WS2=1.0292519898371806 WS3=1.0780506493418733
.alter p000339
.param VTHN=0.47607872114294963 VTHP=-0.45526280512467449 U0N=0.054862915109155988 U0P=0.019923891607616939 RDSWN=104.69107313499656 RDSWP=121.38687926653672 VSATN=81967.37711978193 VSATP=82659.479266099952 ETA0N=0.07633671713838644 ETA0P=0.080323308474045493 WS0=1.0978545062402385 WS1=0.91151542140862385 WS2=1.098932184945201 WS3=0.96229499151518894
.alter p000340
.param VTHN=0.46532031495622522 VTHP=-0.45882402405138312 U0N=0.049523851920271367 U0P=0.021678742760423204 RDSWN=103.95685334697711 RDSWP=116.33836368826906 VSATN=76220.368809566207 VSATP=75778.087269737473 ETA0N=0.08077096562949837 ETA0P=0.073853580951676129 WS0=1.0126436303583908 WS1=1.0928800341709697 WS2=0.91348427543443156 WS3=0.92309546951797039
.alter p000341
.param VTHN=0.45805255605224782 VTHP=-0.4307623956228166 U0N=0.045582813368928422 U0P=0.021503682816241376 RDSWN=108.78816245181586 RDSWP=123.17157832327412 VSATN=75239.426494602478 VSATP=78508.308871999368 ETA0N=0.082079824990592742 ETA0P=0.08537081419807363 WS0=0.9044207365952458 WS1=0.92962379290754682 WS2=1.0747815874795505 WS3=1.0981350307601161
.alter p000342
.param VTHN=0.46889825771068472 VTHP=-0.44155812573622821 U0N=0.051538423087156345 U0P=0.01950769803878017 RDSWN=106.90626736180872 RDSWP=120.79234583413465 VSATN=81392.246581107829 VSATP=76239.170163664021 ETA0N=0.080537664599485193 ETA0P=0.085767237537014845 WS0=1.0910701293410123 WS1=1.0879592994064509 WS2=0.98796631437052551 WS3=0.93331493575321145
.alter p000343
.param VTHN=0.42237083266578157 VTHP=-0.47757696278843526 U0N=0.053593736264472544 U0P=0.020072199271538294 RDSWN=106.4971561972169 RDSWP=126.83596040850293 VSATN=78119.273548431229 VSATP=85140.181013128386 ETA0N=0.086450320064520289 ETA0P=0.078127996513997738 WS0=0.9897583190523721 WS1=0.93580946727497749 WS2=0.92369947219372273 WS3=1.0243493856991392
.alter p000344
.param VTHN=0.44440602587593009 VTHP=-0.45417315413903592 U0N=0.049819370036072286 U0P=0.020429100822740298 RDSWN=91.82815161151288 RDSWP=114.12799833698087 VSATN=82851.81653418261 VSATP=80358.663486668534 ETA0N=0.078345292961622487 ETA0P=0.073571465948225279 WS0=0.90566520276822893 WS1=0.91241529720869807 WS2=0.98317913937821599 WS3=1.0434541643647595
.alter p000345
.param VTHN=0.44274475560732718 VTHP=-0.43808297201331181 U0N=0.050192625479061906 U0P=0.021459652068782684 RDSWN=101.98138823772749 RDSWP=131.03661657458812 VSATN=82840.29748249866 VSATP=72929.782951165238 ETA0N=0.08172501380594227 ETA0P=0.087261785425890512 WS0=1.0897703798941296 WS1=0.94367531047178854 WS2=0.99222697420614003 WS3=1.062444007130352
.alter p000346
.param VTHN=0.46691667009408683 VTHP=-0.45702293451545362 U0N=0.054802302273283116 U0P=0.02098798099568382 RDSWN=108.06328983752532 RDSWP=113.50038539062476 VSATN=76620.752243612398 VSATP=82696.635761995232 ETA0N=0.072787331126467514 ETA0P=0.076689433140919638 WS0=1.0511904857872136 WS1=0.90361496328589097 WS2=0.90885520724352886 WS3=0.99962855615924495
.alter p000347
.param VTHN=0.42977559758035744 VTHP=-0.45278735101900797 U0N=0.046391631266151478 U0P=0.021745895594563549 RDSWN=99.861265548839938 RDSWP=121.1636962063745 VSATN=83355.475388128732 VSATP=80536.682880134918 ETA0N=0.076403353456878709 ETA0P=0.075029586004729643 WS0=1.0681919399490087 WS1=0.94311389792105538 WS2=0.93751307062296652 WS3=1.0877538388403303
.alter p000348
.param VTHN=0.42431015527456151 VTHP=-0.43037755244780324 U0N=0.047877470864742804 U0P=0.01831850099705383 RDSWN=103.9757875581294 RDSWP=110.6551405015533 VSATN=80213.873410721877 VSATP=86314.224717679957 ETA0N=0.074935072883325876 ETA0P=0.082584322145934405 WS0=0.96642383287705524 WS1=1.0315457261181442 WS2=1.0653304366131815 WS3=1.0306849870372197
.alter p000349
.param VTHN=0.42942514372316543 VTHP=-0.45669282388101096 U0N=0.054020457577476227 U0P=0.018557933730460063 RDSWN=94.546284523111126 RDSWP=114.80484036243125 VSATN=82761.557611445023 VSATP=83437.262267812708 ETA0N=0.073079180921053033 ETA0P=0.080742150971156168 WS0=1.0711906129784874 WS1=0.99472441280373369 WS2=0.98172388121122234 WS3=0.9570727616082727
.alter p000350
.param VTHN=0.47731825676158363 VTHP=-0.44017283972207205 U0N=0.05366225469252231 U0P=0.020550106608699631 RDSWN=105.77953751468512 RDSWP=114.90367521671351 VSATN=78478.053449750019 VSATP=77715.54490207613 ETA0N=0.0766515239850587 ETA0P=0.082498204081529219 WS0=1.0141867593789138 WS1=0.9641923883735033 WS2=1.072516742135043 WS3=1.0203732542066848
.alter p000351
.param VTHN=0.45777348138697821 VTHP=-0.46239131463440647 U0N=0.049251346227701095 U0P=0.018363935818825627 RDSWN=99.003458056214669 RDSWP=128.17631599621461 VSATN=84256.403308495399 VSATP=74893.817315406821 ETA0N=0.076251251150029647 ETA0P=0.082355372846501393 WS0=1.0087955588313644 WS1=0.91522096501295513 WS2=0.94409851407394096 WS3=0.94701361879585433
.alter p000352
.param VTHN=0.44936793898843014 VTHP=-0.42177125290280032 U0N=0.052550086673748823 U0P=0.01961223051155021 RDSWN=109.6860510715852 RDSWP=112.9635741448315 VSATN=81749.377417751617 VSATP=77500.709709427465 ETA0N=0.072424307609969985 ETA0P=0.07710818259958746 WS0=0.92392089513541698 WS1=0.99910727242535102 WS2=0.94244071901050885 WS3=0.96708444989063325
.alter p000353
.param VTHN=0.44103791811952348 VTHP=-0.44435252037474576 U0N=0.052817211761416044 U0P=0.020674586544009589 RDSWN=106.63770387515601 RDSWP=108.56550121927133 VSATN=77656.239680869228 VSATP=81110.51835624894 ETA0N=0.084511021717471699 ETA0P=0.0846370472285225 WS0=0.91135650862851136 WS1=0.9635456158457385 WS2=0.91732096446717515 WS3=0.92119270089259497
.alter p000354
.param VTHN=0.45249269784855761 VTHP=-0.45970408268808755 U0N=0.054496517871470224 U0P=0.020009623631612471 RDSWN=101.49362958428473 RDSWP=117.96671143021541 VSATN=77187.031328225668 VSATP=73804.502020972242 ETA0N=0.076430195730034844 ETA0P=0.074328916873624612 WS0=0.94729742630851199 WS1=0.91217801020751232 WS2=0.9582109944599857 WS3=0.91908378570351623
.alter p000355
.param VTHN=0.42038741576220567 VTHP=-0.44532645498054935 U0N=0.046517046026489164 U0P=0.021295237414956134 RDSWN=109.82762264623325 RDSWP=110.52315320634483 VSATN=83091.647554209427 VSATP=78194.700114403211 ETA0N=0.074869581784091851 ETA0P=0.084222313737472687 WS0=1.0533239221515007 WS1=1.0075296264612528 WS2=1.0007692305673552 WS3=0.98926019192956971
.alter p000356
.param VTHN=0.42290414389872633 VTHP=-0.47191102664320234 U0N=0.053497211711782226 U0P=0.019457476149309327 RDSWN=108.59179328123311 RDSWP=116.15280550520923 VSATN=82234.092091167855 VSATP=83882.618181323473 ETA0N=0.074585607556311564 ETA0P=0.080511571028117512 WS0=0.92491553894659539 WS1=1.0899371860674532 WS2=1.0355530669347812 WS3=1.0137414722730831
.alter p000357
.param VTHN=0.47489527993665065 VTHP=-0.43157079237600149 U0N=0.046218475837713428 U0P=0.018140231455357671 RDSWN=99.320012527661646 RDSWP=111.36910044032838 VSATN=79747.52487291221 VSATP=76350.55835584132 ETA0N=0.078862702438878204 ETA0P=0.086630475603611576 WS0=0.91468904881631963 WS1=0.9625792435314342 WS2=0.99722066511535978 WS3=1.0335082488080292
.alter p000358
.param VTHN=0.46641288785081808 VTHP=-0.4214525549563064 U0N=0.048211610242419045 U0P=0.020575524117747834 RDSWN=108.30276850639079 RDSWP=126.09846614983026 VSATN=74649.751343956086 VSATP=73916.242820438129 ETA0N=0.084402377165332013 ETA0P=0.078201541034323807 WS0=0.94405790563721315 WS1=1.000987873592367 WS2=0.92906878089278966 WS3=0.91285558491435992
.alter p000359
.param VTHN=0.42687302079074163 VTHP=-0.45045676160373777 U0N=0.049695455249302779 U0P=0.021634305065366004 RDSWN=104.08280017372201 RDSWP=111.95705410077201 VSATN=85032.559650704628 VSATP=82289.427707507755 ETA0N=0.079323099157260921 ETA0P=0.079786915765263769 WS0=1.0938196802754256 WS1=1.0857049066309818 WS2=0.91403205256273079 WS3=1.0395811000487694
.alter p000360
.param VTHN=0.46523669251511252 VTHP=-0.4613735590327635 U0N=0.047325545002325671 U0P=0.02121318691116001 RDSWN=92.758170049023562 RDSWP=111.78448299380477 VSATN=78290.849240675496 VSATP=79396.550662072972 ETA0N=0.082816676981956508 ETA0P=0.083617426180534388 WS0=0.92842771870947893 WS1=1.0576581282475945 WS2=1.0506228610238697 WS3=1.0652714775200365
.alter p000361
.param VTHN=0.45489962408928281 VTHP=-0.43781433689183269 U0N=0.045229808988895906 U0P=0.020415335545556714 RDSWN=98.467173385183784 RDSWP=118.34439785831749 VSATN=72489.375207360106 VSATP=85087.79668985623 ETA0N=0.086266782029916042 ETA0P=0.075531452225423582 WS0=1.0137617165122217 WS1=0.93303847260244976 WS2=1.0444175839013348 WS3=1.0874763427393712
.alter p000362
.param VTHN=0.42903183077825652 VTHP=-0.46456729128333607 U0N=0.048992807391443988 U0P=0.019391650817423486 RDSWN=101.55799221955066 RDSWP=131.32555226408124 VSATN=75613.164602338802 VSATP=84334.377218244277 ETA0N=0.081940260950442156 ETA0P=0.083248079345614123 WS0=0.967929530949038 WS1=0.95412844130440688 WS2=1.0456814883748566 WS3=0.92396092813483666
.alter p000363
.param VTHN=0.45264617163169935 VTHP=-0.43912538404165097 U0N=0.051574186738634294 U0P=0.021597704762862768 RDSWN=90.392563672569651 RDSWP=131.7664158338537 VSATN=82006.084329185149 VSATP=78428.759068331885 ETA0N=0.076850049390683059 ETA0P=0.082315662930203592 WS0=0.98107032634401348 WS1=0.93077477902314876 WS2=1.0282207457438612 WS3=1.0458326290857012
.alter p000364
.param VTHN=0.46808723115415329 VTHP=-0.47302311957052645 U0N=0.049261875877459692 U0P=0.020635660559750878 RDSWN=102.43272625326235 RDSWP=121.87177126872452 VSATN=78814.761920897668 VSATP=78242.445908296198 ETA0N=0.077170544814416403 ETA0P=0.085720052064001864 WS0=1.0991479267043989 WS1=1.0359996524316861 WS2=1.0232365764554199 WS3=0.91494495009808741
.alter p000365
.param VTHN=0.46956429808712374 VTHP=-0.4281775184785544 U0N=0.052168876838635019 U0P=0.02118180845183355 RDSWN=108.89311564085997 RDSWP=113.15233800523808 VSATN=76743.676946821579 VSATP=75128.874434620768 ETA0N=0.082204263828423982 ETA0P=0.076320878467330336 WS0=1.0553736353974192 WS1=1.059150461003749 WS2=1.0512222012324948 WS3=1.0543504355084226
.alter p000366
.param VTHN=0.47237444852576199 VTHP=-0.43226586910588211 U0N=0.054272027427451811 U0P=0.021590076996293707 RDSWN=102.65141844410532 RDSWP=118.89554595473368 VSATN=72976.630880531258 VSATP=73291.419311077625 ETA0N=0.075291556151627234 ETA0P=0.078369077304727253 WS0=0.93004807270769052 WS1=1.0638697593325117 WS2=1.0112788896952372 WS3=1.0569232080779454
.alter p000367
.param VTHN=0.45681519389728964 VTHP=-0.4706745454759062 U0N=0.052223012071417371 U0P=0.021020154671610988 RDSWN=107.23049318893031 RDSWP=124.58126256555637 VSATN=80813.034548941068 VSATP=72216.973174402461 ETA0N=0.078919097775572544 ETA0P=0.085479613433788043 WS0=1.0241315260792929 WS1=0.93865309352465143 WS2=1.0693280670553955 WS3=1.0999565471995874
.alter p000368
.param VTHN=0.45152879940146196 VTHP=-0.47148754291795281 U0N=0.053931945980705213 U0P=0.018326771569855304 RDSWN=97.207961473553027 RDSWP=126.41404943380084 VSATN=81050.783676736377 VSATP=77512.991848418082 ETA0N=0.080652095387237235 ETA0P=0.082481567085284396 WS0=1.0286125552760408 WS1=1.0986956248518616 WS2=0.98743806028485626 WS3=1.092228561819482
.alter p000369
.param VTHN=0.45440049333796739 VTHP=-0.47106261937076727 U0N=0.049939055495989516 U0P=0.020313926859000801 RDSWN=94.687029191706955 RDSWP=115.59976765107902 VSATN=76382.982922483061 VSATP=75570.803800252339 ETA0N=0.079227746552495787 ETA0P=0.074684109250684069 WS0=1.0017607594285065 WS1=0.90301913642593645 WS2=0.9850692340753493 WS3=0.91456666120194197
.alter p000370
.param VTHN=0.47228945595867422 VTHP=-0.47177864798154295 U0N=0.048896739273028018 U0P=0.021631099227582887 RDSWN=96.883000321946341 RDSWP=115.24023778683815 VSATN=87858.554515951051 VSATP=73584.814064306789 ETA0N=0.078718515053142396 ETA0P=0.081509801216439387 WS0=0.9344814926834466 WS1=0.98721284065383275 WS2=1.0528403854877377 WS3=1.0498288788890857
.alter p000371
.param VTHN=0.47779607049261952 VTHP=-0.42678206683406372 U0N=0.054525215956063619 U0P=0.019058129795066235 RDSWN=100.23677394895637 RDSWP=127.19707992734808 VSATN=79016.839642973689 VSATP=79849.129645057896 ETA0N=0.081530222577309186 ETA0P=0.081887381271366785 WS0=0.92919346765282718 WS1=0.97555092024053269 WS2=0.92228963338376824 WS3=0.92676304825035827
.alter p000372
.param VTHN=0.47898458821757528 VTHP=-0.43001096278740708 U0N=0.045460054018085339 U0P=0.020646058146587095 RDSWN=102.88836070149154 RDSWP=123.34966859204835 VSATN=76128.045533494384 VSATP=80485.669112413074 ETA0N=0.077594485263882698 ETA0P=0.078319494089982539 WS0=0.96935943507960709 WS1=0.97845401990477232 WS2=1.0660170392631285 WS3=0.93060276614088777
.alter p000373
.param VTHN=0.42830550251702215 VTHP=-0.44015960009713334 U0N=0.05444802496273321 U0P=0.018902414860981088 RDSWN=106.13568389370383 RDSWP=122.15163514597842 VSATN=82147.039518613499 VSATP=76402.877734501002 ETA0N=0.074020625605896478 ETA0P=0.082093867247239244 WS0=1.0079832179461712 WS1=1.0754894340325103 WS2=1.0264021789902449 WS3=0.90701544219845376
.alter p000374
.param VTHN=0.46125224303250806 VTHP=-0.42397645320424415 U0N=0.050221370498856152 U0P=0.020330621475190911 RDSWN=108.35940929488189 RDSWP=109.42673067851425 VSATN=72710.869602269828 VSATP=78646.894658131525 ETA0N=0.083136901318577261 ETA0P=0.076819652956516812 WS0=0.91776591147938658 WS1=1.0490415073304618 WS2=1.0311493329050745 WS3=1.0994530325409002
.alter p000375
.param VTHN=0.43499934147522579 VTHP=-0.46222157266046149 U0N=0.051831795967085634 U0P=0.020144639794643694 RDSWN=92.928695087837497 RDSWP=125.37757196862859 VSATN=87694.146029833952 VSATP=80436.014417970029 ETA0N=0.081913445454017866 ETA0P=0.079136923954665317 WS0=0.98934133819481995 WS1=1.017226531245403 WS2=1.0611844451242223 WS3=1.0376863932383005
.alter p000376
.param VTHN=0.42159695303493644 VTHP=-0.46876371448554599 U0N=0.049639199462617918 U0P=0.020433743342553413 RDSWN=99.930147893793148 RDSWP=130.00120812614895 VSATN=74385.523870226141 VSATP=87845.895617177972 ETA0N=0.079005696249450294 ETA0P=0.072044524815374586 WS0=0.92550250199071626 WS1=0.9818608616534823 WS2=0.91627132827585411 WS3=0.90115082247164568
.alter p000377
.param VTHN=0.47417048880058588 VTHP=-0.4410714180768503 U0N=0.048374913008142922 U0P=0.021202231364935258 RDSWN=94.738195334821654 RDSWP=118.29613451621353 VSATN=84122.13740840531 VSATP=87310.326876288018 ETA0N=0.084719206628464341 ETA0P=0.082249001509200087 WS0=1.0858224682450917 WS1=0.96711725545693927 WS2=0.96156529397795543 WS3=0.93201788794084239
.alter p000378
.param VTHN=0.44136512031290803 VTHP=-0.42596384799083342 U0N=0.048821767983581323 U0P=0.02077622410369263 RDSWN=93.895696203587093 RDSWP=128.33015064503826 VSATN=80483.803778122368 VSATP=85778.179341965981 ETA0N=0.074198975319948582 ETA0P=0.075796365583275488 WS0=1.0719621909436832 WS1=1.0908068864412221 WS2=1.0642839820609988 WS3=1.0946554179314008
.alter p000379
.param VTHN=0.45374005480199991 VTHP=-0.45986318229410306 U0N=0.054057605428692451 U0P=0.021380889656296934 RDSWN=100.27714061186489 RDSWP=126.76683794677939 VSATN=85581.251070672792 VSATP=77043.386157811983 ETA0N=0.086496595053936642 ETA0P=0.085962076531664294 WS0=1.0564123466187485 WS1=1.0423890967701177 WS2=0.91902909048642778 WS3=1.0177785441343112
.alter p000380
.param VTHN=0.43665704945102674 VTHP=-0.45351130228394776 U0N=0.049168987232023412 U0P=0.0185406818366846 RDSWN=93.652773158525207 RDSWP=121.64585072942373 VSATN=84720.283300560986 VSATP=87690.776937151153 ETA0N=0.083507889019757128 ETA0P=0.075500597793718413 WS0=1.0183028068395683 WS1=0.9315764932060272 WS2=1.092770289910628 WS3=1.0764328136160406
.alter p000381
.param VTHN=0.45625781552390759 VTHP=-0.47631644649493932 U0N=0.050590324883646627 U0P=0.018528577275725495 RDSWN=98.911920509062142 RDSWP=115.418654125175 VSATN=74960.646842731367 VSATP=78825.698386233737 ETA0N=0.086701479676707424 ETA0P=0.081226498101639344 WS0=0.97488719129858525 WS1=0.92850130571684075 WS2=0.9568208537115811 WS3=1.0682029151954597
.alter p000382
.param VTHN=0.45784340019452652 VTHP=-0.4313297351245724 U0N=0.05138155066684276 U0P=0.019766136304911523 RDSWN=107.12963110156161 RDSWP=127.40563239710622 VSATN=83454.901648735657 VSATP=72089.127798398738 ETA0N=0.080253266856558009 ETA0P=0.084472735551857192 WS0=1.0273520336142334 WS1=1.0573945354449799 WS2=0.96053750103940472 WS3=0.9313000197522795
.alter p000383
.param VTHN=0.47516818587447335 VTHP=-0.45651151352018099 U0N=0.046352382400111192 U0P=0.021015485726688286 RDSWN=109.9717018444713 RDSWP=114.7616577638821 VSATN=78353.961906052806 VSATP=72994.003434364306 ETA0N=0.083340601743351395 ETA0P=0.072621175826461673 WS0=1.0309552432377216 WS1=0.95118862592598741 WS2=0.97678468109149164 WS3=1.0005914719023357
.alter p000384
.param VTHN=0.46757648606050362 VTHP=-0.47830842582335253 U0N=0.052950925571432404 U0P=0.021949059534091493 RDSWN=95.350615821596449 RDSWP=119.9592068137908 VSATN=76018.778003171639 VSATP=78440.856361106242 ETA0N=0.081404695308572361 ETA0P=0.082197555641935843 WS0=1.0787543080216564 WS1=1.0741486226056869 WS2=1.0261733339960195 WS3=0.96600596252104443
.alter p000385
.param VTHN=0.43839202126441468 VTHP=-0.42359483951948773 U0N=0.053368152818934068 U0P=0.020943394003984161 RDSWN=109.22397491924825 RDSWP=118.67168077586562 VSATN=75422.33548595538 VSATP=79424.736682212199 ETA0N=0.079415431734747813 ETA0P=0.081141831321921015 WS0=1.0403365959213851 WS1=0.98858997752621247 WS2=0.96370440857554385 WS3=1.0250928824749954
.alter p000386
.param VTHN=0.46012710318359223 VTHP=-0.43332430462644139 U0N=0.05377615236024183 U0P=0.018516521367374004 RDSWN=105.2535316823993 RDSWP=117.74697407291241 VSATN=75766.88871562753 VSATP=73415.334056108128 ETA0N=0.076119867181154863 ETA0P=0.087024141523772136 WS0=0.96501547890698947 WS1=0.94109454674541726 WS2=0.96261354625838402 WS3=1.0093870712786597
.alter p000387
.param VTHN=0.4629302322577884 VTHP=-0.45202183787462785 U0N=0.048903692565750771 U0P=0.020836253769371909 RDSWN=102.34124535693573 RDSWP=110.72141613309623 VSATN=86661.509613915521 VSATP=77332.173140735016 ETA0N=0.07417103717985471 ETA0P=0.087531901604337936 WS0=0.90998536914437245 WS1=1.0653076939803081 WS2=1.0189201738254616 WS3=0.96749290761155016
.alter p000388
.param VTHN=0.46142374353788562 VTHP=-0.46670510336561144 U0N=0.049123954754977793 U0P=0.020745821178319152 RDSWN=100.91479277350994 RDSWP=130.27047811117569 VSATN=72134.861802281768 VSATP=73776.740710194397 ETA0N=0.082139871950100071 ETA0P=0.080086391940644278 WS0=0.94949163566824502 WS1=1.05392815590893 WS2=1.0410413490433621 WS3=0.91267179616546545
.alter p000389
.param VTHN=0.42013837716926844 VTHP=-0.44810003545160787 U0N=0.048430965555959576 U0P=0.018779460798142147 RDSWN=104.01625427852571 RDSWP=128.09135226460953 VSATN=81295.412319704483 VSATP=87821.030092149944 ETA0N=0.081434548200933571 ETA0P=0.072140128083812011 WS0=0.95594320547228484 WS1=1.0079127792350597 WS2=0.99175468654318055 WS3=0.90044802735806295
.alter p000390
.param VTHN=0.43941183949464907 VTHP=-0.42696644984293813 U0N=0.045860395365290955 U0P=0.018282704957560209 RDSWN=97.698502349211864 RDSWP=122.10253901064942 VSATN=73523.29789024817 VSATP=85163.01648287884 ETA0N=0.079148159541370833 ETA0P=0.075956837651192433 WS0=1.0615949410736327 WS1=0.91379279953725467 WS2=1.0564429381131775 WS3=0.91364296574797488
.alter p000391
.param VTHN=0.46326333297021138 VTHP=-0.44491742783459748 U0N=0.054381335924525528 U0P=0.018819739010823257 RDSWN=99.202241482102878 RDSWP=110.90386457797901 VSATN=81552.108412112211 VSATP=72675.661607836752 ETA0N=0.086640594040912108 ETA0P=0.079214374074149746 WS0=1.0197948226026874 WS1=0.92429085340824335 WS2=0.98547816943227518 WS3=1.0838967362473018
.alter p000392
.param VTHN=0.42990236501640527 VTHP=-0.44683010212259117 U0N=0.046012591403331547 U0P=0.019989061209474655 RDSWN=90.654987234842963 RDSWP=108.89821490260017 VSATN=78612.901134069034 VSATP=80813.269103592713 ETA0N=0.07332767310182714 ETA0P=0.081485225913183967 WS0=1.0295088137671455 WS1=0.98203542658501941 WS2=1.035989977394854 WS3=1.00636990940335
.alter p000393
.param VTHN=0.47301485802559884 VTHP=-0.43175086443192867 U0N=0.047466564514223042 U0P=0.021142247738772151 RDSWN=98.211607601379839 RDSWP=126.6662177764816 VSATN=87268.518569600943 VSATP=74699.36118246078 ETA0N=0.085536941597104538 ETA0P=0.082036224094523755 WS0=1.0114254323945482 WS1=0.97745548679944538 WS2=0.90441682169789128 WS3=0.98789872967157299
.alter p000394
.param VTHN=0.44580346322319697 VTHP=-0.44368680937774124 U0N=0.045324804197995026 U0P=0.020127899950236523 RDSWN=95.68975686947806 RDSWP=130.41690305214311 VSATN=77257.034819978391 VSATP=80683.51025059032 ETA0N=0.085683365496738384 ETA0P=0.079551988722270026 WS0=0.95041387161688895 WS1=0.92057737635465164 WS2=1.0596026787060959 WS3=1.0926795633791413
.alter p000395
.param VTHN=0.44783260613376075 VTHP=-0.4343741654637151 U0N=0.051687988583179863 U0P=0.020971313211711785 RDSWN=109.86695265397059 RDSWP=116.04969971069374 VSATN=72554.453322015353 VSATP=84757.604030409871 ETA0N=0.081576268463316295 ETA0P=0.079948514799912371 WS0=0.97965713052930403 WS1=0.96105819665106318 WS2=1.0756894609867647 WS3=1.0341785000214825
.alter p000396
.param VTHN=0.43389498262006415 VTHP=-0.46576155203632924 U0N=0.051073926099014323 U0P=0.020853703156775233 RDSWN=90.358751672947577 RDSWP=111.55841505727699 VSATN=80636.689338980519 VSATP=85964.447371166927 ETA0N=0.082233901080741176 ETA0P=0.087783161844246921 WS0=1.0460304370840612 WS1=0.99276579468981541 WS2=1.0442668177768204 WS3=1.0147608685603748
.alter p000397
.param VTHN=0.44892467576100609 VTHP=-0.43771781428471146 U0N=0.049882644721928424 U0P=0.020215255143370355 RDSWN=107.05229378101089 RDSWP=112.42018530400738 VSATN=82511.421754840543 VSATP=87944.261836308768 ETA0N=0.079554042272278316 ETA0P=0.082990378070067455 WS0=0.93601007865259411 WS1=1.0004908278277642 WS2=0.99783997091910981 WS3=1.0807930581616083
.alter p000398
.param VTHN=0.44246658192030686 VTHP=-0.47682497693618414 U0N=0.050677005652204565 U0P=0.021006918933094521 RDSWN=107.42522784097174 RDSWP=126.96709219917778 VSATN=86386.018018563816 VSATP=87992.362728759952 ETA0N=0.084257412888888078 ETA0P=0.084835973426415787 WS0=0.90040061376349856 WS1=0.95039275926234512 WS2=0.95422120140918376 WS3=0.91836313901592614
.alter p000399
.param VTHN=0.43262525218173326 VTHP=-0.43834306877205742 U0N=0.048522835786522771 U0P=0.021422928370664684 RDSWN=102.01512851468694 RDSWP=115.10132396768198 VSATN=80567.422651293382 VSATP=76045.442587888465 ETA0N=0.080907177964215163 ETA0P=0.075968610971579739 WS0=0.92069141147372191 WS1=0.92602364334451448 WS2=1.084339355777538 WS3=0.99801337498540199
.alter p000400
.param VTHN=0.43810164795185075 VTHP=-0.46595665749707943 U0N=0.051881420427296598 U0P=0.019861593056313385 RDSWN=98.58601387681378 RDSWP=124.63736012355741 VSATN=76521.0831017647 VSATP=85453.853866278354 ETA0N=0.08760014273824443 ETA0P=0.082966207346003254 WS0=1.0131155123024631 WS1=0.97702127577956022 WS2=0.9177071484519167 WS3=1.0114229080904955
.alter p000401
.param VTHN=0.43775259802013794 VTHP=-0.45246500423692942 U0N=0.053260477124610447 U0P=0.021375877797340924 RDSWN=104.12161275750995 RDSWP=125.63547153774429 VSATN=86235.485757321323 VSATP=78068.114720627156 ETA0N=0.074337263725219732 ETA0P=0.078447363550365384 WS0=1.0754858145840966 WS1=1.003599380156557 WS2=0.95596210635120771 WS3=1.0089559696443253
.alter p000402
.param VTHN=0.43366751550603361 VTHP=-0.46334384958230052 U0N=0.05380353563798318 U0P=0.018179929923478066 RDSWN=95.963929667046131 RDSWP=117.63648174547006 VSATN=80102.925888208134 VSATP=75260.960150493032 ETA0N=0.073675564419942802 ETA0P=0.084595882923587717 WS0=1.0030631830159027 WS1=1.0461270322112761 WS2=1.0097545947504798 WS3=1.0755733227956712
.alter p000403
.param VTHN=0.43923505739177682 VTHP=-0.43923528584742844 U0N=0.045247271052312674 U0P=0.019746878649997617 RDSWN=102.75847863625798 RDSWP=109.24987951634833 VSATN=82908.613356642192 VSATP=87039.550579317875 ETA0N=0.084238322417898887 ETA0P=0.072482447630571434 WS0=0.96232008297954297 WS1=1.0304713845016866 WS2=1.0922391567739864 WS3=1.0011958369605529
.alter p000404
.param VTHN=0.44982996270067177 VTHP=-0.47702689452778196 U0N=0.050307669962113784 U0P=0.020912855426359785 RDSWN=97.336136561409546 RDSWP=121.09954975284688 VSATN=75029.340593703077 VSATP=81984.450651885505 ETA0N=0.087670810070628463 ETA0P=0.074566475053794518 WS0=1.0237243773285276 WS1=1.0509579141316165 WS2=1.0772789550846793 WS3=1.0757172064626161
.alter p000405
.param VTHN=0.45546217190717436 VTHP=-0.42609227649973835 U0N=0.046553965242060423 U0P=0.021693976791422005 RDSWN=106.92992870732016 RDSWP=116.53664451487806 VSATN=83743.239264663003 VSATP=82540.157892446485 ETA0N=0.087079274848174265 ETA0P=0.074975888121792594 WS0=1.0571423864312863 WS1=1.0716510618617761 WS2=1.0707682608727285 WS3=0.94143483653249116
.alter p000406
.param VTHN=0.4492290263294621 VTHP=-0.43315920860935037 U0N=0.048485218861482708 U0P=0.021786224616180436 RDSWN=106.06110739000445 RDSWP=108.37972748172558 VSATN=77019.172378292511 VSATP=72568.703833927968 ETA0N=0.077449886081273983 ETA0P=0.074389889569666079 WS0=0.92212364222056153 WS1=0.96302457367059191 WS2=0.95258953563283111 WS3=1.0733421841476478
.alter p000407
.param VTHN=0.4448273713142718 VTHP=-0.44481247729976159 U0N=0.053250902067542523 U0P=0.019855270070415959 RDSWN=105.63273217642832 RDSWP=126.69534013606065 VSATN=84824.605307998805 VSATP=86832.560498074585 ETA0N=0.087419246562005115 ETA0P=0.075202395974328665 WS0=1.0788054671285761 WS1=0.91776381139089824 WS2=0.99582965314643479 WS3=0.95154300210828857
.alter p000408
.param VTHN=0.45998016566228339 VTHP=-0.46396921484752768 U0N=0.050407206694878762 U0P=0.018464669976410844 RDSWN=103.02671115050063 RDSWP=131.06475965396521 VSATN=77246.439536315374 VSATP=81784.19194513683 ETA0N=0.085514489198867699 ETA0P=0.078799679443921355 WS0=0.99556565041154488 WS1=1.0816745356113269 WS2=0.99263496868125323 WS3=0.98727156761480561
.alter p000409
.param VTHN=0.46218186981611553 VTHP=-0.43645810734550811 U0N=0.045440384522219525 U0P=0.021645597260799131 RDSWN=109.57771089559097 RDSWP=124.10081729432653 VSATN=82710.119523206362 VSATP=75218.563447917899 ETA0N=0.086101252823750765 ETA0P=0.080711186011998989 WS0=1.0110531086304855 WS1=0.9235299823401848 WS2=1.0036606391166203 WS3=0.98832421429450013
.alter p000410
.param VTHN=0.43099845639979473 VTHP=-0.44998626877039261 U0N=0.0494133225390197 U0P=0.021848832462523522 RDSWN=97.784756649356183 RDSWP=118.62389244126501 VSATN=76819.08359212584 VSATP=77852.104916288721 ETA0N=0.08039050322450017 ETA0P=0.085395240038645209 WS0=0.95273110995344823 WS1=1.0905895395950518 WS2=0.97841928137703493 WS3=1.0648001026372891
.alter p000411
.param VTHN=0.43026754165292747 VTHP=-0.46788720245948467 U0N=0.045642180053415825 U0P=0.020617507471498195 RDSWN=108.11980994942455 RDSWP=126.55594257630997 VSATN=85283.238037736795 VSATP=87054.550090406454 ETA0N=0.084803654636605913 ETA0P=0.085582798420404685 WS0=0.94067834732008326 WS1=0.94269425687525055 WS2=1.006332534900108 WS3=0.98657592278255435
.alter p000412
.param VTHN=0.42532590855844893 VTHP=-0.46823379815067706 U0N=0.049014878332028687 U0P=0.019090577845498346 RDSWN=92.142907281801513 RDSWP=124.25953776554056 VSATN=87837.960701957083 VSATP=87874.995328850564 ETA0N=0.077814343298732644 ETA0P=0.083911343688209655 WS0=0.90085064207957233 WS1=0.99051889199520082 WS2=1.0937733461610424 WS3=1.0901260515669773
.alter p000413
.param VTHN=0.42333946676274264 VTHP=-0.42074342467665093 U0N=0.050458596233623185 U0P=0.018482770184365289 RDSWN=92.695064688704875 RDSWP=108.69754221749277 VSATN=80463.30981715559 VSATP=74574.508504985715 ETA0N=0.073153038025553771 ETA0P=0.078057869996852811 WS0=1.0302272021936671 WS1=0.95883693889720245 WS2=0.90029233641992823 WS3=1.0815115531825104
.alter p000414
.param VTHN=0.44606106739922774 VTHP=-0.47970319187355809 U0N=0.049189417391590759 U0P=0.02037578893495039 RDSWN=93.13663514186895 RDSWP=121.77803440442869 VSATN=79870.599008750898 VSATP=74463.121101844241 ETA0N=0.074323580685444188 ETA0P=0.081778122168116751 WS0=1.0974537318820241 WS1=1.0070672737689397 WS2=0.98320950478910074 WS3=1.031257756278438
.alter p000415
.param VTHN=0.45412833707865008 VTHP=-0.4355875437051146 U0N=0.04534066146714448 U0P=0.018007426174114237 RDSWN=108.72644262811914 RDSWP=131.19896673505892 VSATN=86507.878986792275 VSATP=80387.17501417709 ETA0N=0.076882730717895156 ETA0P=0.077221105855602837 WS0=0.99823637878927518 WS1=1.0701970812622015 WS2=0.97786613566715452 WS3=1.0802693680331421
.alter p000416
.param VTHN=0.42577131030862869 VTHP=-0.43009175082713835 U0N=0.050653838124327971 U0P=0.018751939549852849 RDSWN=91.981553953750421 RDSWP=118.46363053809192 VSATN=73846.773833406478 VSATP=75914.075796439807 ETA0N=0.08175784687899347 ETA0P=0.080526912059655634 WS0=0.98589252940930872 WS1=1.0612411058271825 WS2=1.0350822496386585 WS3=0.96285476850134977
.alter p000417
.param VTHN=0.44359976782352895 VTHP=-0.47929851146208008 U0N=0.051543946731328921 U0P=0.018461308735947965 RDSWN=105.45041189815873 RDSWP=109.84261363836038 VSATN=86769.416177250241 VSATP=83677.984191611278 ETA0N=0.076779445905050897 ETA0P=0.085096235272756837 WS0=1.0679479312760114 WS1=1.0825115712931996 WS2=0.98618585320323326 WS3=1.0623776608803879
.alter p000418
.param VTHN=0.43965687326476088 VTHP=-0.47849472751755545 U0N=0.047625899362947768 U0P=0.018086184519394255 RDSWN=96.722408454736154 RDSWP=120.24477288958973 VSATN=78321.896104488755 VSATP=87419.461040105205 ETA0N=0.077328594547431101 ETA0P=0.083409605683686716 WS0=1.0802188574022937 WS1=0.99685508566141445 WS2=1.0176358023103704 WS3=1.0356951148626297
.alter p000419
.param VTHN=0.43875824596374963 VTHP=-0.4443994977674211 U0N=0.050896499346070025 U0P=0.02099247588261734 RDSWN=95.278918972596585 RDSWP=109.73497878432076 VSATN=73024.412924430027 VSATP=72043.478981323904 ETA0N=0.083842922934182731 ETA0P=0.076112846891997765 WS0=0.95649546555992826 WS1=1.0874439698501224 WS2=0.95986809349533497 WS3=0.97636542489540745
.alter p000420
.param VTHN=0.47802868041906055 VTHP=-0.43960083833291086 U0N=0.052294879803981356 U0P=0.019808676829378539 RDSWN=94.834212538476734 RDSWP=123.67174949165637 VSATN=75916.057094931777 VSATP=82917.156563040451 ETA0N=0.080746675457646203 ETA0P=0.072712623157068584 WS0=1.0157166548769394 WS1=0.96049944520122987 WS2=1.090261173879338 WS3=0.98510245792214246
.alter p000421
.param VTHN=0.45582585270220061 VTHP=-0.47045678505677185 U0N=0.049712025707903888 U0P=0.019838626573547808 RDSWN=98.973560139007944 RDSWP=127.02420547750808 VSATN=76117.985785607467 VSATP=85422.880023046542 ETA0N=0.084688197614759347 ETA0P=0.077769226191115134 WS0=0.97293988674448695 WS1=1.0934666477504744 WS2=0.91028701404811518 WS3=1.0027381985524451
.alter p000422
.param VTHN=0.47334627975490201 VTHP=-0.44572581254935317 U0N=0.051491015449559523 U0P=0.021554904673728625 RDSWN=95.753316283322519 RDSWP=128.5529470398522 VSATN=72937.160532809532 VSATP=79810.863959678347 ETA0N=0.087642169650493429 ETA0P=0.084049930525958827 WS0=0.99373457327437009 WS1=1.0134612681059041 WS2=0.96834854931838688 WS3=0.90007531599443846
.alter p000423
.param VTHN=0.47816793828724918 VTHP=-0.45310124888164732 U0N=0.051122501526763058 U0P=0.018929250900517874 RDSWN=100.19378137066386 RDSWP=127.57325949387811 VSATN=72117.552886262914 VSATP=76746.409773477761 ETA0N=0.075630914931728008 ETA0P=0.076573060402868404 WS0=1.0152053190728183 WS1=1.0361978901867979 WS2=1.0403441371857522 WS3=0.90408824381481689
.alter p000424
.param VTHN=0.46172893047617802 VTHP=-0.43300624299180085 U0N=0.050514835604857554 U0P=0.020739182916295146 RDSWN=96.179042260666776 RDSWP=119.20072590605709 VSATN=77069.880102149735 VSATP=79750.092115745123 ETA0N=0.079905432052322645 ETA0P=0.073078054957446417 WS0=0.96253326924622107 WS1=1.0529012517151606 WS2=1.0914867765388199 WS3=0.91711004052508405
.alter p000425
.param VTHN=0.47998376091741729 VTHP=-0.44728580014657654 U0N=0.048314578922079021 U0P=0.021763176450726916 RDSWN=97.465544238924977 RDSWP=128.82955461037943 VSATN=74133.083814638521 VSATP=73203.705871317608 ETA0N=0.076160885221685307 ETA0P=0.085179564348792952 WS0=1.0748934571820259 WS1=0.92276684587838964 WS2=0.91383096063279889 WS3=1.0233363275512417
.alter p000426
.param VTHN=0.46543785321178066 VTHP=-0.47661327015443433 U0N=0.051001847418262546 U0P=0.021543678738492125 RDSWN=101.3005013922478 RDSWP=119.75109827736779 VSATN=83181.270343146723 VSATP=77436.758585327654 ETA0N=0.074722694047846788 ETA0P=0.079360051424096273 WS0=1.0094707381194505 WS1=1.0412583249099647 WS2=1.0849061651796024 WS3=1.0407327603749192
.alter p000427
.param VTHN=0.43069412527147372 VTHP=-0.4414480492500184 U0N=0.0501396730426584 U0P=0.019142046877915216 RDSWN=108.40747117489477 RDSWP=115.63344981046716 VSATN=80926.15096006672 VSATP=76627.035357283385 ETA0N=0.08015529478305955 ETA0P=0.072126473118623052 WS0=0.95208085385800811 WS1=0.91678560301908141 WS2=1.0628010554717635 WS3=0.90856108580342632
.alter p000428
.param VTHN=0.45940089791675409 VTHP=-0.44965146130255251 U0N=0.051410446387524421 U0P=0.021613849013531937 RDSWN=91.291063368617671 RDSWP=115.84242914363257 VSATN=77444.854248244694 VSATP=79284.409235648956 ETA0N=0.078839511046305794 ETA0P=0.078475177805638036 WS0=0.96147227805343605 WS1=0.97171091896284789 WS2=1.0719035973753366 WS3=0.96949883582662422
.alter p000429
.param VTHN=0.43240290936010389 VTHP=-0.47913873436236643 U0N=0.050005653905788629 U0P=0.021867842744467902 RDSWN=98.42914160515555 RDSWP=117.35168315408208 VSATN=86006.286117715208 VSATP=82037.388585788081 ETA0N=0.085027455539037539 ETA0P=0.086003333226536693 WS0=0.9869658495870206 WS1=0.9612235624688793 WS2=1.055417173535204 WS3=0.90180393674264969
.alter p000430
.param VTHN=0.43553330407668722 VTHP=-0.42660891082218461 U0N=0.051770361068106355 U0P=0.019563285567876329 RDSWN=96.874097011919275 RDSWP=121.42769124823396 VSATN=79139.775887451469 VSATP=76089.405818407278 ETA0N=0.077514001232244528 ETA0P=0.085679199422016239 WS0=1.0312664806294283 WS1=1.0216120037429715 WS2=1.0508128980215188 WS3=1.0462881758000382
.alter p000431
.param VTHN=0.47639352291604314 VTHP=-0.43636110583288046 U0N=0.046703202342139712 U0P=0.021400917971226372 RDSWN=91.368531926684071 RDSWP=116.16990879672088 VSATN=76293.950486697096 VSATP=84141.960109110893 ETA0N=0.072980904154366255 ETA0P=0.077182563190519665 WS0=1.037475502137688 WS1=0.9244159033362892 WS2=0.91871644244779072 WS3=0.96077461298280087
.alter p000432
.param VTHN=0.43228651438986765 VTHP=-0.4470005473563593 U0N=0.053346311543073816 U0P=0.021800150665981684 RDSWN=98.951211825421751 RDSWP=108.79816287150858 VSATN=74308.491258455484 VSATP=76959.047834874757 ETA0N=0.072370152496203113 ETA0P=0.078087905084150311 WS0=1.0685215571594804 WS1=1.0923463352628175 WS2=1.0119980732326264 WS3=1.0698925393782681
.alter p000433
.param VTHN=0.47265897185729067 VTHP=-0.46618437729688939 U0N=0.053306167229324977 U0P=0.019171660725193863 RDSWN=109.78526942244163 RDSWP=122.52773114212053 VSATN=87060.187949379964 VSATP=81407.824797658031 ETA0N=0.083293259414141674 ETA0P=0.075154329418570059 WS0=0.93641652137442544 WS1=0.92763272796113228 WS2=0.92090399458893824 WS3=0.91551093898491998
.alter p000434
.param VTHN=0.42754995984374972 VTHP=-0.47285292520327682 U0N=0.046577990852869455 U0P=0.020108735790963998 RDSWN=99.96168349751035 RDSWP=117.38743039737966 VSATN=80954.826553427643 VSATP=85101.388035395314 ETA0N=0.079768835706555269 ETA0P=0.07452663255210519 WS0=0.99513022697541942 WS1=1.0596747126459269 WS2=1.0423353371379867 WS3=1.0788038782093734
.alter p000435
.param VTHN=0.4629831506567707 VTHP=-0.45317619285367189 U0N=0.047999501906751181 U0P=0.01937757665384365 RDSWN=96.62817193920236 RDSWP=114.99380123258305 VSATN=72835.953189528125 VSATP=80076.223371429354 ETA0N=0.077607335211720349 ETA0P=0.076175625704532082 WS0=1.0956827746270374 WS1=0.96391910148600313 WS2=0.91695116051398229 WS3=1.01938743127019
.alter p000436
.param VTHN=0.43209856162739929 VTHP=-0.47575929333382366 U0N=0.04647245001424502 U0P=0.019965880619110352 RDSWN=103.16416029645774 RDSWP=116.01573308704631 VSATN=78401.250500948663 VSATP=72444.329480927583 ETA0N=0.076468066840686327 ETA0P=0.08089139192106666 WS0=0.97057134309046655 WS1=1.0279566770032726 WS2=1.0214171564194217 WS3=1.0868045943219233
.alter p000437
.param VTHN=0.42194338827188482 VTHP=-0.45024442104666046 U0N=0.049844684305070129 U0P=0.019178132073586124 RDSWN=103.56865024526377 RDSWP=124.36300578261528 VSATN=81328.239704401189 VSATP=72398.960881007981 ETA0N=0.084434032349828464 ETA0P=0.075660992676743255 WS0=0.90393687557615432 WS1=0.951735350416405 WS2=1.0187191945604952 WS3=1.0159917174019784
.alter p000438
.param VTHN=0.42053894591686547 VTHP=-0.42505198505004638 U0N=0.052821595406842774 U0P=0.021091246796601654 RDSWN=109.12873491209169 RDSWP=125.46992821150839 VSATN=83577.006742543483 VSATP=76115.847979158978 ETA0N=0.073303399847902434 ETA0P=0.087098881918386745 WS0=0.93482794713072037 WS1=1.044840063454326 WS2=0.94459299468040392 WS3=1.0538496836187536
.alter p000439
.param VTHN=0.42445500726799013 VTHP=-0.43703536571546908 U0N=0.054243656354750265 U0P=0.018252738228429249 RDSWN=107.46293316202535 RDSWP=112.78558996427641 VSATN=75286.749459778614 VSATP=81197.972849036771 ETA0N=0.072808101836287026 ETA0P=0.087988795832656549 WS0=1.0560695175984451 WS1=1.0480341166199685 WS2=0.9931618808390783 WS3=0.90125561651674613
.alter p000440
.param VTHN=0.45796381908593969 VTHP=-0.47515417466231114 U0N=0.054161385125702108 U0P=0.018765171774846628 RDSWN=90.880808720014301 RDSWP=131.72733060259674 VSATN=83878.763785062038 VSATP=79566.102615884112 ETA0N=0.084981188750315267 ETA0P=0.080416136059640778 WS0=1.0070612745190084 WS1=1.0319755019905552 WS2=1.0658577886236402 WS3=0.97584099340696984
.alter p000441
.param VTHN=0.44857629017581657 VTHP=-0.45816753613821104 U0N=0.048248076850877862 U0P=0.021193121171884245 RDSWN=92.242280851070916 RDSWP=108.28305760153457 VSATN=82460.96800038754 VSATP=84561.613766139315 ETA0N=0.073994259833452633 ETA0P=0.085149091844988797 WS0=0.90403093690093983 WS1=1.0349258314060144 WS2=0.91548655364907072 WS3=0.97382123463309378
.alter p000442
.param VTHN=0.47718897394192322 VTHP=-0.47881112250223418 U0N=0.052367537202975246 U0P=0.018378133230328022 RDSWN=95.017653664166389 RDSWP=114.62140310737568 VSATN=81879.805723586411 VSATP=86465.906688932693 ETA0N=0.082922360842615631 ETA0P=0.085661374051855699 WS0=0.99969325281009969 WS1=1.0808636640295262 WS2=1.0479673887890348 WS3=0.94848217766564213
.alter p000443
.param VTHN=0.42845718383783743 VTHP=-0.46642145883328012 U0N=0.051250878200504016 U0P=0.021702027566255694 RDSWN=106.44916863427204 RDSWP=114.45128838785155 VSATN=82140.757324104285 VSATP=80468.577976802917 ETA0N=0.077560750807254761 ETA0P=0.078972206029310293 WS0=0.94009064444607771 WS1=0.94055526173837467 WS2=0.99531250341588007 WS3=1.0318707727566043
.alter p000444
.param VTHN=0.45842931351870159 VTHP=-0.47380190790448468 U0N=0.045411396729556776 U0P=0.020796447645492145 RDSWN=99.778112000414581 RDSWP=120.07732695827325 VSATN=77695.001963204268 VSATP=81557.71866879506 ETA0N=0.074824494004505721 ETA0P=0.086823536159787468 WS0=0.90630896987315146 WS1=0.94996678700307624 WS2=1.0970556835018124 WS3=0.91038869822247215
.alter p000445
.param VTHN=0.44692346737845007 VTHP=-0.43056185236992878 U0N=0.052664576916945198 U0P=0.019886064234815017 RDSWN=109.7522062059105 RDSWP=113.90526772309434 VSATN=78451.531613858824 VSATP=78659.560123546966 ETA0N=0.073192880731400178 ETA0P=0.078620326762849371 WS0=0.94873138840876081 WS1=1.0237967492809401 WS2=0.92697010431114613 WS3=1.0578623804834144
.alter p000446
.param VTHN=0.42346824792804511 VTHP=-0.45395447537212869 U0N=0.050174157184420767 U0P=0.018668863158081368 RDSWN=106.76380461158988 RDSWP=114.69240240689668 VSATN=77720.105790061687 VSATP=83413.080181142417 ETA0N=0.078313519150698188 ETA0P=0.083535922324716155 WS0=0.92148882840686863 WS1=0.92817671862267825 WS2=1.0148776049613977 WS3=0.98133904024406826
.alter p000447
.param VTHN=0.47547924503520594 VTHP=-0.42256141746219278 U0N=0.053506440016696168 U0P=0.021384600598958175 RDSWN=103.61603577060716 RDSWP=123.94258941197513 VSATN=83750.418969543141 VSATP=81451.588792356677 ETA0N=0.08484137731890827 ETA0P=0.077404685436846241 WS0=0.96322765282937794 WS1=1.0972562610216716 WS2=0.96579341403478769 WS3=0.98414000042654937
.alter p000448
.param VTHN=0.42728697095600532 VTHP=-0.43321623380681462 U0N=0.053113910831482411 U0P=0.018207226338819157 RDSWN=106.96388734870945 RDSWP=114.65691675517418 VSATN=79688.151432091094 VSATP=83538.582826823549 ETA0N=0.085402790123310979 ETA0P=0.087116464586400211 WS0=0.98141990360100606 WS1=1.0730418219596662 WS2=0.96450014459927957 WS3=0.91237985975849101
.alter p000449
.param VTHN=0.47794625874893581 VTHP=-0.44318239406418508 U0N=0.049315935516050097 U0P=0.019532866862724922 RDSWN=103.81628341490442 RDSWP=129.43279818078398 VSATN=82477.011027693748 VSATP=75471.703461853787 ETA0N=0.080007944825011099 ETA0P=0.084669297861286727 WS0=1.0500461582803062 WS1=1.0658262123506885 WS2=0.99378216293700716 WS3=0.99569709382039795
.alter p000450
.param VTHN=0.43348723631147451 VTHP=-0.44344867804657523 U0N=0.045037101225992214 U0P=0.020501007862062402 RDSWN=95.891680871677323 RDSWP=109.19996863931513 VSATN=73064.791600299563 VSATP=82746.290330628719 ETA0N=0.082338124989422556 ETA0P=0.083709669821507085 WS0=0.92937905125824105 WS1=1.0431503325642499 WS2=1.0382895227028277 WS3=0.995480056918705
.alter p000451
.param VTHN=0.46471581121003414 VTHP=-0.43816093312366944 U0N=0.047093923055520986 U0P=0.018270747530506941 RDSWN=101.88831151308017 RDSWP=128.46912657485316 VSATN=72826.873142191936 VSATP=87277.872476243108 ETA0N=0.073586646901726227 ETA0P=0.084294214411735971 WS0=0.98512640940819829 WS1=0.97943554433909408 WS2=0.94095998675188597 WS3=0.96889957844261543
.alter p000452
.param VTHN=0.45089502515092728 VTHP=-0.45145445564273412 U0N=0.051440267395657012 U0P=0.01912763492408151 RDSWN=108.70595950644517 RDSWP=122.94960987637279 VSATN=79261.852311543538 VSATP=79106.94656977494 ETA0N=0.08381057282438141 ETA0P=0.082704484897900971 WS0=0.99845488043324915 WS1=1.0368258050513348 WS2=0.94059318965303274 WS3=1.0189986661637547
.alter p000453
.param VTHN=0.43953664828144962 VTHP=-0.45851180771426192 U0N=0.04740043442919533 U0P=0.021072814087080536 RDSWN=95.18507356558321 RDSWP=112.4968978113283 VSATN=82052.671213052352 VSATP=77245.058516419464 ETA0N=0.083423613661487248 ETA0P=0.076309007100615486 WS0=0.97729912625105608 WS1=1.077544046835335 WS2=1.0051106797916545 WS3=1.0141572726415693
.alter p000454
.param VTHN=0.44153266527341795 VTHP=-0.4408753402480593 U0N=0.047025610763308745 U0P=0.018155100214428812 RDSWN=104.72533501677138 RDSWP=121.45319196251873 VSATN=74914.72634907387 VSATP=85302.915053070945 ETA0N=0.07414001897723424 ETA0P=0.08273871554510917 WS0=1.0486183403439566 WS1=0.99387180458670055 WS2=0.98254583849929755 WS3=1.042469516505423
.alter p000455
.param VTHN=0.42479920053639286 VTHP=-0.42196191786843701 U0N=0.050119937217999011 U0P=0.019346197479480718 RDSWN=98.392505075685364 RDSWP=125.5067244817116 VSATN=78069.917838937443 VSATP=75282.09907044108 ETA0N=0.084468607101691448 ETA0P=0.08116510701645456 WS0=0.91673622586290171 WS1=1.0137782600216303 WS2=0.97956879664128016 WS3=0.94495739567779158
.alter p000456
.param VTHN=0.45902953323309331 VTHP=-0.44549766996980494 U0N=0.046374954844980859 U0P=0.020605157841868324 RDSWN=101.44052704391171 RDSWP=109.08715211062444 VSATN=76084.854858073755 VSATP=86737.809994588766 ETA0N=0.08404614620334297 ETA0P=0.084710904894107278 WS0=1.0318238607556669 WS1=0.96479820942372918 WS2=1.0489995868667361 WS3=1.0484595922229554
.alter p000457
.param VTHN=0.47872116584179847 VTHP=-0.44050289940645454 U0N=0.05457629417084256 U0P=0.020772635377855057 RDSWN=105.39910166847432 RDSWP=114.35123405467303 VSATN=73785.491902091992 VSATP=86614.743366787996 ETA0N=0.084647784182665442 ETA0P=0.087289096027863958 WS0=0.90550673715663232 WS1=1.0720783542556394 WS2=0.98135579656730576 WS3=0.98322836307716988
.alter p000458
.param VTHN=0.45864422152233586 VTHP=-0.46835968404435269 U0N=0.04728002258016268 U0P=0.019893401001489251 RDSWN=100.10449564161209 RDSWP=130.47673917708121 VSATN=87396.746588832291 VSATP=84380.775792149856 ETA0N=0.082625661286248084 ETA0P=0.082537466012915617 WS0=1.0146245606493354 WS1=1.03733825316305 WS2=0.91063628522361517 WS3=0.93468225530438476
.alter p000459
.param VTHN=0.47010278006613865 VTHP=-0.43874219154954386 U0N=0.052723000716797093 U0P=0.019736399899298016 RDSWN=104.83936445770664 RDSWP=120.68465668344949 VSATN=80411.869911726448 VSATP=83053.94925742592 ETA0N=0.085334511869943619 ETA0P=0.085023834344957333 WS0=0.97608469476874593 WS1=1.0662763393911814 WS2=1.0209350690072618 WS3=1.0267816572058355
.alter p000460
.param VTHN=0.45118272135462956 VTHP=-0.46275768756311453 U0N=0.048099001830047228 U0P=0.021163470109080526 RDSWN=100.44208994791236 RDSWP=125.15409366662038 VSATN=85104.135087070405 VSATP=83818.210230228389 ETA0N=0.085416778245243713 ETA0P=0.078288097454397979 WS0=0.98293880462057448 WS1=1.0992668642974091 WS2=1.0393286934967807 WS3=0.94789577073341258
.alter p000461
.param VTHN=0.44115292550827812 VTHP=-0.44780106364636779 U0N=0.050321050189260204 U0P=0.021274428104846435 RDSWN=90.226322993163365 RDSWP=128.70449694922678 VSATN=74476.383102833395 VSATP=82323.202739391229 ETA0N=0.087029534005200151 ETA0P=0.085512768229410618 WS0=0.96729895255519227 WS1=1.0023031952323118 WS2=0.97425592548760565 WS3=0.92818372748531053
.alter p000462
.param VTHN=0.43104301838736958 VTHP=-0.45398309274075516 U0N=0.052300582746675241 U0P=0.020543746979396871 RDSWN=93.584125972932355 RDSWP=119.36147055975783 VSATN=72329.212387758511 VSATP=84260.068550063239 ETA0N=0.080195105236127134 ETA0P=0.078005479764513164 WS0=1.0601446836574304 WS1=0.98283030884019118 WS2=1.0200385631104623 WS3=0.91122559361714084
.alter p000463
.param VTHN=0.45523200471677705 VTHP=-0.43519251621263921 U0N=0.051160207303449286 U0P=0.019292573165693338 RDSWN=103.91747305596968 RDSWP=130.80768093854556 VSATN=76038.561034767481 VSATP=79947.759756999687 ETA0N=0.081047030113404001 ETA0P=0.076777645651270585 WS0=0.99421296035039575 WS1=1.0146377685264969 WS2=1.0323386461925939 WS3=0.98707180355377555
.alter p000464
.param VTHN=0.47459943646086433 VTHP=-0.44737164210149993 U0N=0.047491469915648926 U0P=0.018755602381654503 RDSWN=99.160808349949022 RDSWP=126.59780340181487 VSATN=85559.336449018578 VSATP=73694.725591140043 ETA0N=0.078538962687934075 ETA0P=0.086139199351557408 WS0=1.0008431225065177 WS1=1.0255008248935105 WS2=0.95210360490819668 WS3=1.0573674059860461
.alter p000465
.param VTHN=0.42509376751788441 VTHP=-0.44455420258125317 U0N=0.047600080807592773 U0P=0.018732807171854535 RDSWN=97.496234524863169 RDSWP=110.15740804974575 VSATN=73560.428174712913 VSATP=84852.265051954615 ETA0N=0.082547121122931513 ETA0P=0.072427907401635197 WS0=0.94988945902828514 WS1=1.0926022433462608 WS2=1.0156554934306723 WS3=1.003690875341851
.alter p000466
.param VTHN=0.42373299266427344 VTHP=-0.45441472858038084 U0N=0.045684104014677512 U0P=0.019795888170457319 RDSWN=108.93050440168176 RDSWP=113.06239880359547 VSATN=79785.660095595085 VSATP=84944.428870046657 ETA0N=0.077665148580335616 ETA0P=0.084948847328133861 WS0=1.0047706358399437 WS1=1.0812415097242984 WS2=0.9060790125390179 WS3=1.0469671492016843
.alter p000467
.param VTHN=0.4477018269161841 VTHP=-0.46698717066506801 U0N=0.048954944583355475 U0P=0.018654624722694357 RDSWN=93.855212196284157 RDSWP=116.4296899200116 VSATN=82924.433047670333 VSATP=81411.639119974352 ETA0N=0.072197263441731788 ETA0P=0.074877742446357962 WS0=0.97718341939436981 WS1=0.97584186055489885 WS2=0.9122686081414505 WS3=1.0207731567715201
.alter p000468
.param VTHN=0.47588403881578395 VTHP=-0.42742180540645858 U0N=0.04563607128775491 U0P=0.019819505952889768 RDSWN=101.60732147887424 RDSWP=124.07791074142696 VSATN=74832.615811822339 VSATP=73094.684431551112 ETA0N=0.075217472224912416 ETA0P=0.080299992174456672 WS0=1.043932241673432 WS1=1.0584491465947048 WS2=1.0785965624667238 WS3=0.93697272583088365
.alter p000469
.param VTHN=0.42306555545213698 VTHP=-0.44309453622021888 U0N=0.050900098236083199 U0P=0.019184756295830843 RDSWN=91.651984793435417 RDSWP=127.46391510599302 VSATN=79475.58295937239 VSATP=83114.838597081209 ETA0N=0.082420691405611812 ETA0P=0.07304468360416351 WS0=1.0123346303370531 WS1=0.99625413095111615 WS2=1.076318551868171 WS3=1.0000529451952573
.alter p000470
.param VTHN=0.43486270129991039 VTHP=-0.47098668661952126 U0N=0.046248458556176653 U0P=0.020381044338908322 RDSWN=91.621020315057606 RDSWP=125.11632781123765 VSATN=78529.614366744048 VSATP=85044.378293343456 ETA0N=0.073746329706526503 ETA0P=0.080115261220504788 WS0=1.0930722598535625 WS1=0.91357244626916212 WS2=0.9947464336941938 WS3=0.92530102637558753
.alter p000471
.param VTHN=0.46185125277040423 VTHP=-0.42695501602176539 U0N=0.050281587062712081 U0P=0.021338240360450511 RDSWN=92.535644615269419 RDSWP=119.12776278587381 VSATN=85490.77807579744 VSATP=74916.755235703909 ETA0N=0.073023039440818061 ETA0P=0.072644940173780648 WS0=1.0382724190091404 WS1=0.99975587060826854 WS2=0.9128504665470879 WS3=0.91341964915718998
.alter p000472
.param VTHN=0.43307019868499519 VTHP=-0.45232317454334375 U0N=0.047935359198387179 U0P=0.019434447947718921 RDSWN=96.407993945782692 RDSWP=115.36659793409001 VSATN=74450.119835280319 VSATP=84479.870143401145 ETA0N=0.075540949483577938 ETA0P=0.081753225693044662 WS0=1.0893966501984935 WS1=0.98922186504460785 WS2=0.93065039796879701 WS3=0.9986368276400176
.alter p000473
.param VTHN=0.44080038657733295 VTHP=-0.43379928834787829 U0N=0.053220957077049547 U0P=0.018721439278167665 RDSWN=94.860475320351298 RDSWP=131.90742764822491 VSATN=75173.501851487497 VSATP=73056.803651434282 ETA0N=0.080731439303101823 ETA0P=0.074339706188336935 WS0=1.0922563670354375 WS1=0.95201845680444097 WS2=1.0838044445822812 WS3=0.94114056681021918
.alter p000474
.param VTHN=0.44556898587499888 VTHP=-0.42722984823013915 U0N=0.048342375132911494 U0P=0.020227774515744985 RDSWN=107.9216094737245 RDSWP=129.75553011342635 VSATN=80354.077644977311 VSATP=76469.2550308707 ETA0N=0.075831693194560262 ETA0P=0.085731160536823878 WS0=1.0970899923772177 WS1=1.0364335263342965 WS2=0.94492357753496192 WS3=0.93199378528840249
.alter p000475
.param VTHN=0.46710153884721795 VTHP=-0.44980576052370247 U0N=0.050496938958360951 U0P=0.018739700011620952 RDSWN=103.55050674062751 RDSWP=123.28887824182775 VSATN=77564.059670542367 VSATP=85482.926748294864 ETA0N=0.081007991362030435 ETA0P=0.077027139630472946 WS0=0.96285799756266877 WS1=0.99783205958772281 WS2=0.98872772500194206 WS3=0.95458335398450855
.alter p000476
.param VTHN=0.46152912835752591 VTHP=-0.47013169911396513 U0N=0.048869128852674332 U0P=0.021808939147670171 RDSWN=96.807104874625367 RDSWP=117.67748675179978 VSATN=77953.147934196386 VSATP=80724.380294752962 ETA0N=0.073910837792443396 ETA0P=0.082426456014943666 WS0=0.93378900851464364 WS1=1.0727523721056764 WS2=0.9962932868778599 WS3=1.0084372254993696
.alter p000477
.param VTHN=0.44728738548213165 VTHP=-0.47270871658079028 U0N=0.047837210996890971 U0P=0.021570513621685539 RDSWN=100.86199482215581 RDSWP=112.87291043733981 VSATN=84891.885664514179 VSATP=85381.127833461564 ETA0N=0.079936286859612973 ETA0P=0.072213820792665764 WS0=1.0542388885289908 WS1=1.0104316123439947 WS2=0.92599730662760482 WS3=0.97518110084352261
.alter p000478
.param VTHN=0.47176762374675457 VTHP=-0.44749049071951513 U0N=0.05111733782626502 U0P=0.020731371952400719 RDSWN=106.32453652268183 RDSWP=112.53434100338814 VSATN=82960.486376352463 VSATP=82867.237209279265 ETA0N=0.072729586306647637 ETA0P=0.073732238544144665 WS0=0.94443700295545296 WS1=0.91426641011260523 WS2=0.97336499633189211 WS3=0.94311850889449622
.alter p000479
.param VTHN=0.42095762278439086 VTHP=-0.47448366717342078 U0N=0.049424625582360923 U0P=0.019332656563782729 RDSWN=91.12528075529633 RDSWP=128.75168229194574 VSATN=85969.901640288255 VSATP=81334.123946639476 ETA0N=0.079332577871609009 ETA0P=0.074540445867644162 WS0=0.92591118213914059 WS1=1.0259717988452237 WS2=1.0405206711753201 WS3=0.98452995070108029
.alter p000480
.param VTHN=0.45300796353674039 VTHP=-0.46996264555540007 U0N=0.051362332717089447 U0P=0.021041739806682693 RDSWN=95.065546720452744 RDSWP=128.61037946693253 VSATN=86945.79592337487 VSATP=74124.133772644927 ETA0N=0.074294981046450284 ETA0P=0.083288038407312442 WS0=1.0879178748654688 WS1=1.0766427313805138 WS2=1.0810206742761208 WS3=0.9056267526796038
.alter p000481
.param VTHN=0.42128516760148882 VTHP=-0.43393991163834139 U0N=0.048540098911979974 U0P=0.01888443689963297 RDSWN=107.82648805101812 RDSWP=123.82230952749312 VSATN=74742.683409519814 VSATP=85349.335904132662 ETA0N=0.077033441336989028 ETA0P=0.077792946610053801 WS0=1.0082128486470785 WS1=1.0553970062217459 WS2=0.91197633964197 WS3=1.0795251366421652
.alter p000482
.param VTHN=0.43786759016683252 VTHP=-0.44179240879586734 U0N=0.053657493039324759 U0P=0.020892854141977796 RDSWN=105.4949868327618 RDSWP=115.45600246041079 VSATN=86417.123006946495 VSATP=73368.318048019719 ETA0N=0.074613774055054233 ETA0P=0.077205018683779075 WS0=0.96580898932132353 WS1=0.90986610567847104 WS2=0.93256907401945111 WS3=0.9223194421356421
.alter p000483
.param VTHN=0.42214538799809875 VTHP=-0.44357560129528356 U0N=0.046662863506513927 U0P=0.01971546807846946 RDSWN=103.20059320750917 RDSWP=125.31554613820174 VSATN=80683.947658964738 VSATP=84504.041008960572 ETA0N=0.075750511941256385 ETA0P=0.074238991808066326 WS0=1.0860915964433886 WS1=0.93927338738044586 WS2=0.90932470478816407 WS3=0.98984839042843387
.alter p000484
.param VTHN=0.44066556783508498 VTHP=-0.47588732365055558 U0N=0.053542240778588608 U0P=0.021226306047431663 RDSWN=91.224751785921981 RDSWP=117.45966032441677 VSATN=86990.766416788829 VSATP=75823.998804490358 ETA0N=0.073622573434856481 ETA0P=0.077305110637612667 WS0=1.0000860257778763 WS1=1.0029608002845039 WS2=0.94307133581231284 WS3=1.0847515161890391
.alter p000485
.param VTHN=0.47523560088758632 VTHP=-0.45907472982848219 U0N=0.054695154703102253 U0P=0.020416133321178087 RDSWN=100.78030163959679 RDSWP=130.77681408034323 VSATN=79418.586527582171 VSATP=75985.706011843533 ETA0N=0.072857923844030656 ETA0P=0.083095205351284201 WS0=0.95478720238744241 WS1=1.0084204143235687 WS2=0.98591638126359227 WS3=0.92850558398135541
.alter p000486
.param VTHN=0.46278690185247817 VTHP=-0.45729846178171679 U0N=0.049063397345956994 U0P=0.020047161681652881 RDSWN=91.34039567607914 RDSWP=120.97067219782082 VSATN=84674.674491437356 VSATP=74618.638245508002 ETA0N=0.087431108363965573 ETA0P=0.083730004180140316 WS0=0.95544662851882589 WS1=1.0881004857849919 WS2=1.0497359874082819 WS3=1.0049873284286546
.alter p000487
.param VTHN=0.47086234783434605 VTHP=-0.43261620938631029 U0N=0.049990420150562341 U0P=0.021330721486548791 RDSWN=100.32341150943844 RDSWP=116.65530319648433 VSATN=76720.182766170445 VSATP=87384.131467839004 ETA0N=0.074780607744246982 ETA0P=0.086416356053460347 WS0=0.9977638957697641 WS1=1.0330567480077135 WS2=1.0100741636004842 WS3=0.92320586272076122
.alter p000488
.param VTHN=0.47944502820578461 VTHP=-0.44891930364367688 U0N=0.052452757303860523 U0P=0.0194714635799043 RDSWN=90.743490605154619 RDSWP=128.36999660733611 VSATN=72276.413978678247 VSATP=83555.279315850305 ETA0N=0.079512628399667468 ETA0P=0.079037425742364886 WS0=1.0693778798876572 WS1=1.0841787839088817 WS2=0.94940863349947868 WS3=1.0743679493115137
.alter p000489
.param VTHN=0.44915425261025055 VTHP=-0.4734989755600687 U0N=0.054150386257809949 U0P=0.019957413060099606 RDSWN=91.447982827655096 RDSWP=131.52723720125249 VSATN=80032.655740485789 VSATP=80953.744485515781 ETA0N=0.074505121047098471 ETA0P=0.084283103927178096 WS0=0.91744214817582281 WS1=0.97839355183917376 WS2=0.95174354044075438 WS3=1.0165607675838122
.alter p000490
.param VTHN=0.45827741310426251 VTHP=-0.45790066578754635 U0N=0.05491816037499217 U0P=0.021408970877144374 RDSWN=92.862720806812121 RDSWP=131.49128969475726 VSATN=72632.511245169313 VSATP=78148.837816998523 ETA0N=0.07849795117200864 ETA0P=0.075934947012022094 WS0=0.93308112139872945 WS1=0.91905039216841311 WS2=1.0030418472493769 WS3=1.0098897425060329
.alter p000491
.param VTHN=0.46841963514778689 VTHP=-0.46809460164851063 U0N=0.04597874030306872 U0P=0.020367788573044405 RDSWN=93.624662226565732 RDSWP=108.38422518463393 VSATN=82311.784779158304 VSATP=74057.436495893591 ETA0N=0.085373003551738727 ETA0P=0.074253333042787306 WS0=1.0631571283185859 WS1=1.038822843140047 WS2=1.0239965220062677 WS3=1.0320578496988255
.alter p000492
.param VTHN=0.45590366189690046 VTHP=-0.47675161059432902 U0N=0.048737730813975574 U0P=0.021505744888731086 RDSWN=99.256614899435135 RDSWP=109.53249548753969 VSATN=73496.953662375046 VSATP=73975.927440590691 ETA0N=0.077767179344681969 ETA0P=0.083568783440233399 WS0=0.97954703372660856 WS1=0.90509277768343921 WS2=1.0044042102219768 WS3=0.90461432057887414
.alter p000493
.param VTHN=0.45977469994579717 VTHP=-0.42418084529906863 U0N=0.048041682344107488 U0P=0.021308775074347554 RDSWN=98.170918971991412 RDSWP=122.65508895819556 VSATN=73383.211361209716 VSATP=72706.875265237148 ETA0N=0.085899443097486386 ETA0P=0.082864360853437402 WS0=1.0261686150146043 WS1=1.0264240465996162 WS2=0.90701351971877975 WS3=1.0910599963571432
.alter p000494
.param VTHN=0.45073789446555063 VTHP=-0.47224772017007111 U0N=0.047913308660799694 U0P=0.019664850947784515 RDSWN=101.20319228290113 RDSWP=116.6360395032368 VSATN=86604.404376986786 VSATP=87744.976044297742 ETA0N=0.085772610121709308 ETA0P=0.081095057025451306 WS0=1.0714344182712825 WS1=1.0601947137572856 WS2=0.90599040406592912 WS3=0.95993494979019656
.alter p000495
.param VTHN=0.47911366617140744 VTHP=-0.42093648387739213 U0N=0.051914007847006588 U0P=0.018174331242344917 RDSWN=101.01021628568881 RDSWP=131.95841596897367 VSATN=73018.105453775657 VSATP=75757.309779406758 ETA0N=0.087553625842773999 ETA0P=0.074158421184512505 WS0=0.93329917667313589 WS1=1.0441433611687532 WS2=1.0493943690420293 WS3=1.0532494496936478
.alter p000496
.param VTHN=0.42955131168675736 VTHP=-0.44789917463566875 U0N=0.049946841777297954 U0P=0.02126715860783206 RDSWN=106.54559642888812 RDSWP=119.59420872007716 VSATN=87618.882997177498 VSATP=75028.881218377355 ETA0N=0.078761124291748585 ETA0P=0.079862048587959089 WS0=0.98058651830696097 WS1=1.0213849434253777 WS2=0.95542706933145394 WS3=0.9143902942136185
.alter p000497
.param VTHN=0.44344811571214354 VTHP=-0.43463573938732419 U0N=0.052137196236907678 U0P=0.020534609110464543 RDSWN=96.953391913518033 RDSWP=113.62838169291831 VSATN=75836.440076564089 VSATP=87920.984789597307 ETA0N=0.079549232113757015 ETA0P=0.072266054166185964 WS0=1.0723173805284034 WS1=1.0288562160921493 WS2=0.92510248604994638 WS3=1.0149448681980831
.alter p000498
.param VTHN=0.46695521880545676 VTHP=-0.43973949784806499 U0N=0.048506457220945445 U0P=0.019049975789692881 RDSWN=107.9663376142754 RDSWP=113.59574902395602 VSATN=87670.629567412194 VSATP=84971.635605744828 ETA0N=0.072583224086637546 ETA0P=0.077251092603369514 WS0=0.9420860602247999 WS1=0.91961708472749903 WS2=1.0516768397183696 WS3=0.98636492261220876
.alter p000499
.param VTHN=0.42263298755897488 VTHP=-0.44505185579443707 U0N=0.053471321787389545 U0P=0.018015366577581782 RDSWN=103.33394005186523 RDSWP=115.52200491727038 VSATN=73928.546709432194 VSATP=79499.302117095183 ETA0N=0.07701707492823813 ETA0P=0.086242763933461059 WS0=0.9187805276658092 WS1=0.92121031559027255 WS2=1.0874317380042393 WS3=0.90389308526057022
.end
