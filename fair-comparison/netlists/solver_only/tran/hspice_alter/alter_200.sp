* fair-comparison p000000 tran
.option nomod method=gear reltol=1e-6 vntol=1e-9 abstol=1e-13 gmin=1e-12 itl1=200
.param VTHN=0.45126483051096039 VTHP=-0.43712328775058912 U0N=0.054472227924512562 U0P=0.019642227633496968 RDSWN=95.093588416662513 RDSWP=125.06632680402315 VSATN=87504.447322012653 VSATP=75147.443178696412 ETA0N=0.086119024107108172 ETA0P=0.072375500135660659 WS0=0.9297506302192986 WS1=1.0376459501931772 WS2=0.95303198059391914 WS3=1.02285909173834
.temp 25
.model NM NMOS (LEVEL=54 VERSION=4.7.0 TNOM=25 TOXE=1.5e-09 DTOX=0 EPSROX=3.8999999999999999 XJ=9.9999999999999995e-08 NSD=1e+20 NGATE=0 PHIN=0 K1=0.53000000000000003 K2=-0.018599999999999998 K3=0 K3B=0 W0=2.5000000000000002e-06 DVT0=2.2000000000000002 DVT1=0.53000000000000003 DVT2=-0.032000000000000001 DVT0W=0 DVT1W=5300000 DVT2W=-0.032000000000000001 UA=1.0000000000000001e-09 UB=1.0000000000000001e-18 UC=-4.6500000000000001e-11 A0=1 AGS=0 B0=0 B1=0 KETA=-0.047 A1=0 A2=1 PRWG=0 PRWB=0 WR=1 DWG=0 DWB=0 VOFF=-0.080000000000000002 NFACTOR=1 ETAB=-0.070000000000000007 PCLM=1.3 PDIBLC1=0.39000000000000001 PDIBLC2=0.0086 PDIBLCB=0 DROUT=0.56000000000000005 PVAG=0 DELTA=0.01 MOBMOD=0 CAPMOD=2 RDSMOD=0 RGATEMOD=0 NDEP=1.7e+17 VTH0='VTHN' U0='U0N' RDSW='RDSWN' VSAT='VSATN' ETA0='ETA0N')
.model PM PMOS (LEVEL=54 VERSION=4.7.0 TNOM=25 TOXE=1.5e-09 DTOX=0 EPSROX=3.8999999999999999 XJ=9.9999999999999995e-08 NSD=1e+20 NGATE=0 PHIN=0 K1=0.53000000000000003 K2=-0.018599999999999998 K3=0 K3B=0 W0=2.5000000000000002e-06 DVT0=2.2000000000000002 DVT1=0.53000000000000003 DVT2=-0.032000000000000001 DVT0W=0 DVT1W=5300000 DVT2W=-0.032000000000000001 UA=1.0000000000000001e-09 UB=1.0000000000000001e-18 UC=-4.6500000000000001e-11 A0=1 AGS=0 B0=0 B1=0 KETA=-0.047 A1=0 A2=1 PRWG=0 PRWB=0 WR=1 DWG=0 DWB=0 VOFF=-0.080000000000000002 NFACTOR=1 ETAB=-0.070000000000000007 PCLM=1.3 PDIBLC1=0.39000000000000001 PDIBLC2=0.0086 PDIBLCB=0 DROUT=0.56000000000000005 PVAG=0 DELTA=0.01 MOBMOD=0 CAPMOD=2 RDSMOD=0 RGATEMOD=0 NDEP=1.2e+17 VTH0='VTHP' U0='U0P' RDSW='RDSWP' VSAT='VSATP' ETA0='ETA0P')
VDD vdd 0 1.8
VA00 a00_src 0 PWL(0n 0 9.9n 0 10n 1.8 19.9n 1.8 20n 0 29.9n 0 30n 1.8 40n 1.8)
RIN_A00 a00_src a00 10
VA01 a01_src 0 PWL(0n 0 9.9n 0 10n 1.8 19.9n 1.8 20n 1.8 29.9n 1.8 30n 1.8 40n 1.8)
RIN_A01 a01_src a01 10
VA02 a02_src 0 PWL(0n 0 9.9n 0 10n 1.8 19.9n 1.8 20n 0 29.9n 0 30n 1.8 40n 1.8)
RIN_A02 a02_src a02 10
VA03 a03_src 0 PWL(0n 0 9.9n 0 10n 1.8 19.9n 1.8 20n 1.8 29.9n 1.8 30n 1.8 40n 1.8)
RIN_A03 a03_src a03 10
VA04 a04_src 0 PWL(0n 0 9.9n 0 10n 1.8 19.9n 1.8 20n 0 29.9n 0 30n 1.8 40n 1.8)
RIN_A04 a04_src a04 10
VA05 a05_src 0 PWL(0n 0 9.9n 0 10n 1.8 19.9n 1.8 20n 1.8 29.9n 1.8 30n 1.8 40n 1.8)
RIN_A05 a05_src a05 10
VA06 a06_src 0 PWL(0n 0 9.9n 0 10n 1.8 19.9n 1.8 20n 0 29.9n 0 30n 1.8 40n 1.8)
RIN_A06 a06_src a06 10
VA07 a07_src 0 PWL(0n 0 9.9n 0 10n 1.8 19.9n 1.8 20n 1.8 29.9n 1.8 30n 1.8 40n 1.8)
RIN_A07 a07_src a07 10
VA08 a08_src 0 PWL(0n 0 9.9n 0 10n 1.8 19.9n 1.8 20n 0 29.9n 0 30n 1.8 40n 1.8)
RIN_A08 a08_src a08 10
VA09 a09_src 0 PWL(0n 0 9.9n 0 10n 1.8 19.9n 1.8 20n 1.8 29.9n 1.8 30n 1.8 40n 1.8)
RIN_A09 a09_src a09 10
VA10 a10_src 0 PWL(0n 0 9.9n 0 10n 1.8 19.9n 1.8 20n 0 29.9n 0 30n 1.8 40n 1.8)
RIN_A10 a10_src a10 10
VA11 a11_src 0 PWL(0n 0 9.9n 0 10n 1.8 19.9n 1.8 20n 1.8 29.9n 1.8 30n 1.8 40n 1.8)
RIN_A11 a11_src a11 10
VA12 a12_src 0 PWL(0n 0 9.9n 0 10n 1.8 19.9n 1.8 20n 0 29.9n 0 30n 1.8 40n 1.8)
RIN_A12 a12_src a12 10
VA13 a13_src 0 PWL(0n 0 9.9n 0 10n 1.8 19.9n 1.8 20n 1.8 29.9n 1.8 30n 1.8 40n 1.8)
RIN_A13 a13_src a13 10
VA14 a14_src 0 PWL(0n 0 9.9n 0 10n 1.8 19.9n 1.8 20n 0 29.9n 0 30n 1.8 40n 1.8)
RIN_A14 a14_src a14 10
VA15 a15_src 0 PWL(0n 0 9.9n 0 10n 1.8 19.9n 1.8 20n 1.8 29.9n 1.8 30n 1.8 40n 1.8)
RIN_A15 a15_src a15 10
VB00 b00_src 0 PWL(0n 0 9.9n 0 10n 1.8 19.9n 1.8 20n 1.8 29.9n 1.8 30n 1.8 40n 1.8)
RIN_B00 b00_src b00 10
VB01 b01_src 0 PWL(0n 0 9.9n 0 10n 0 19.9n 0 20n 0 29.9n 0 30n 1.8 40n 1.8)
RIN_B01 b01_src b01 10
VB02 b02_src 0 PWL(0n 0 9.9n 0 10n 0 19.9n 0 20n 1.8 29.9n 1.8 30n 1.8 40n 1.8)
RIN_B02 b02_src b02 10
VB03 b03_src 0 PWL(0n 0 9.9n 0 10n 0 19.9n 0 20n 0 29.9n 0 30n 1.8 40n 1.8)
RIN_B03 b03_src b03 10
VB04 b04_src 0 PWL(0n 0 9.9n 0 10n 0 19.9n 0 20n 1.8 29.9n 1.8 30n 1.8 40n 1.8)
RIN_B04 b04_src b04 10
VB05 b05_src 0 PWL(0n 0 9.9n 0 10n 0 19.9n 0 20n 0 29.9n 0 30n 1.8 40n 1.8)
RIN_B05 b05_src b05 10
VB06 b06_src 0 PWL(0n 0 9.9n 0 10n 0 19.9n 0 20n 1.8 29.9n 1.8 30n 1.8 40n 1.8)
RIN_B06 b06_src b06 10
VB07 b07_src 0 PWL(0n 0 9.9n 0 10n 0 19.9n 0 20n 0 29.9n 0 30n 1.8 40n 1.8)
RIN_B07 b07_src b07 10
VB08 b08_src 0 PWL(0n 0 9.9n 0 10n 0 19.9n 0 20n 1.8 29.9n 1.8 30n 1.8 40n 1.8)
RIN_B08 b08_src b08 10
VB09 b09_src 0 PWL(0n 0 9.9n 0 10n 0 19.9n 0 20n 0 29.9n 0 30n 1.8 40n 1.8)
RIN_B09 b09_src b09 10
VB10 b10_src 0 PWL(0n 0 9.9n 0 10n 0 19.9n 0 20n 1.8 29.9n 1.8 30n 1.8 40n 1.8)
RIN_B10 b10_src b10 10
VB11 b11_src 0 PWL(0n 0 9.9n 0 10n 0 19.9n 0 20n 0 29.9n 0 30n 1.8 40n 1.8)
RIN_B11 b11_src b11 10
VB12 b12_src 0 PWL(0n 0 9.9n 0 10n 0 19.9n 0 20n 1.8 29.9n 1.8 30n 1.8 40n 1.8)
RIN_B12 b12_src b12 10
VB13 b13_src 0 PWL(0n 0 9.9n 0 10n 0 19.9n 0 20n 0 29.9n 0 30n 1.8 40n 1.8)
RIN_B13 b13_src b13 10
VB14 b14_src 0 PWL(0n 0 9.9n 0 10n 0 19.9n 0 20n 1.8 29.9n 1.8 30n 1.8 40n 1.8)
RIN_B14 b14_src b14 10
VB15 b15_src 0 PWL(0n 0 9.9n 0 10n 0 19.9n 0 20n 0 29.9n 0 30n 1.8 40n 1.8)
RIN_B15 b15_src b15 10
VCIN cin_src 0 PWL(0n 0 9.9n 0 10n 0 19.9n 0 20n 1.8 29.9n 1.8 30n 1.8 40n 1.8)
RIN_CIN cin_src cin 10
MN_FA00_X0_IA FA00_X0_ab a00 0 0 NM W='1.1999999999999999e-06*WS0' L=1.8e-7
MP_FA00_X0_IA FA00_X0_ab a00 vdd vdd PM W='2.3999999999999999e-06*WS0' L=1.8e-7
MN_FA00_X0_IB FA00_X0_bb b00 0 0 NM W='1.1999999999999999e-06*WS0' L=1.8e-7
MP_FA00_X0_IB FA00_X0_bb b00 vdd vdd PM W='2.3999999999999999e-06*WS0' L=1.8e-7
MN_FA00_X0_00A p00 FA00_X0_ab FA00_X0_n00 0 NM W='1.7999999999999999e-06*WS1' L=1.8e-7
MN_FA00_X0_00B FA00_X0_n00 FA00_X0_bb 0 0 NM W='1.7999999999999999e-06*WS1' L=1.8e-7
MN_FA00_X0_11A p00 a00 FA00_X0_n11 0 NM W='1.7999999999999999e-06*WS1' L=1.8e-7
MN_FA00_X0_11B FA00_X0_n11 b00 0 0 NM W='1.7999999999999999e-06*WS1' L=1.8e-7
MP_FA00_X0_01A p00 a00 FA00_X0_p01 vdd PM W='3.5999999999999998e-06*WS1' L=1.8e-7
MP_FA00_X0_01B FA00_X0_p01 FA00_X0_bb vdd vdd PM W='3.5999999999999998e-06*WS1' L=1.8e-7
MP_FA00_X0_10A p00 FA00_X0_ab FA00_X0_p10 vdd PM W='3.5999999999999998e-06*WS1' L=1.8e-7
MP_FA00_X0_10B FA00_X0_p10 b00 vdd vdd PM W='3.5999999999999998e-06*WS1' L=1.8e-7
MN_FA00_X1_IA FA00_X1_ab p00 0 0 NM W='1.1999999999999999e-06*WS0' L=1.8e-7
MP_FA00_X1_IA FA00_X1_ab p00 vdd vdd PM W='2.3999999999999999e-06*WS0' L=1.8e-7
MN_FA00_X1_IB FA00_X1_bb cin 0 0 NM W='1.1999999999999999e-06*WS0' L=1.8e-7
MP_FA00_X1_IB FA00_X1_bb cin vdd vdd PM W='2.3999999999999999e-06*WS0' L=1.8e-7
MN_FA00_X1_00A sum00 FA00_X1_ab FA00_X1_n00 0 NM W='1.7999999999999999e-06*WS1' L=1.8e-7
MN_FA00_X1_00B FA00_X1_n00 FA00_X1_bb 0 0 NM W='1.7999999999999999e-06*WS1' L=1.8e-7
MN_FA00_X1_11A sum00 p00 FA00_X1_n11 0 NM W='1.7999999999999999e-06*WS1' L=1.8e-7
MN_FA00_X1_11B FA00_X1_n11 cin 0 0 NM W='1.7999999999999999e-06*WS1' L=1.8e-7
MP_FA00_X1_01A sum00 p00 FA00_X1_p01 vdd PM W='3.5999999999999998e-06*WS1' L=1.8e-7
MP_FA00_X1_01B FA00_X1_p01 FA00_X1_bb vdd vdd PM W='3.5999999999999998e-06*WS1' L=1.8e-7
MP_FA00_X1_10A sum00 FA00_X1_ab FA00_X1_p10 vdd PM W='3.5999999999999998e-06*WS1' L=1.8e-7
MP_FA00_X1_10B FA00_X1_p10 cin vdd vdd PM W='3.5999999999999998e-06*WS1' L=1.8e-7
MN_FA00_NAB_A nab00 a00 FA00_NAB_mid 0 NM W='2.3999999999999999e-06*WS2' L=1.8e-7
MN_FA00_NAB_B FA00_NAB_mid b00 0 0 NM W='2.3999999999999999e-06*WS2' L=1.8e-7
MP_FA00_NAB_A nab00 a00 vdd vdd PM W='4.7999999999999998e-06*WS2' L=1.8e-7
MP_FA00_NAB_B nab00 b00 vdd vdd PM W='4.7999999999999998e-06*WS2' L=1.8e-7
MN_FA00_NPC_A npc00 p00 FA00_NPC_mid 0 NM W='2.3999999999999999e-06*WS2' L=1.8e-7
MN_FA00_NPC_B FA00_NPC_mid cin 0 0 NM W='2.3999999999999999e-06*WS2' L=1.8e-7
MP_FA00_NPC_A npc00 p00 vdd vdd PM W='4.7999999999999998e-06*WS2' L=1.8e-7
MP_FA00_NPC_B npc00 cin vdd vdd PM W='4.7999999999999998e-06*WS2' L=1.8e-7
MN_FA00_COUT_A c01 nab00 FA00_COUT_mid 0 NM W='7.9999999999999996e-06*WS3' L=1.8e-7
MN_FA00_COUT_B FA00_COUT_mid npc00 0 0 NM W='7.9999999999999996e-06*WS3' L=1.8e-7
MP_FA00_COUT_A c01 nab00 vdd vdd PM W='1.5999999999999999e-05*WS3' L=1.8e-7
MP_FA00_COUT_B c01 npc00 vdd vdd PM W='1.5999999999999999e-05*WS3' L=1.8e-7
MN_FA01_X0_IA FA01_X0_ab a01 0 0 NM W='1.1999999999999999e-06*WS0' L=1.8e-7
MP_FA01_X0_IA FA01_X0_ab a01 vdd vdd PM W='2.3999999999999999e-06*WS0' L=1.8e-7
MN_FA01_X0_IB FA01_X0_bb b01 0 0 NM W='1.1999999999999999e-06*WS0' L=1.8e-7
MP_FA01_X0_IB FA01_X0_bb b01 vdd vdd PM W='2.3999999999999999e-06*WS0' L=1.8e-7
MN_FA01_X0_00A p01 FA01_X0_ab FA01_X0_n00 0 NM W='1.7999999999999999e-06*WS1' L=1.8e-7
MN_FA01_X0_00B FA01_X0_n00 FA01_X0_bb 0 0 NM W='1.7999999999999999e-06*WS1' L=1.8e-7
MN_FA01_X0_11A p01 a01 FA01_X0_n11 0 NM W='1.7999999999999999e-06*WS1' L=1.8e-7
MN_FA01_X0_11B FA01_X0_n11 b01 0 0 NM W='1.7999999999999999e-06*WS1' L=1.8e-7
MP_FA01_X0_01A p01 a01 FA01_X0_p01 vdd PM W='3.5999999999999998e-06*WS1' L=1.8e-7
MP_FA01_X0_01B FA01_X0_p01 FA01_X0_bb vdd vdd PM W='3.5999999999999998e-06*WS1' L=1.8e-7
MP_FA01_X0_10A p01 FA01_X0_ab FA01_X0_p10 vdd PM W='3.5999999999999998e-06*WS1' L=1.8e-7
MP_FA01_X0_10B FA01_X0_p10 b01 vdd vdd PM W='3.5999999999999998e-06*WS1' L=1.8e-7
MN_FA01_X1_IA FA01_X1_ab p01 0 0 NM W='1.1999999999999999e-06*WS0' L=1.8e-7
MP_FA01_X1_IA FA01_X1_ab p01 vdd vdd PM W='2.3999999999999999e-06*WS0' L=1.8e-7
MN_FA01_X1_IB FA01_X1_bb c01 0 0 NM W='1.1999999999999999e-06*WS0' L=1.8e-7
MP_FA01_X1_IB FA01_X1_bb c01 vdd vdd PM W='2.3999999999999999e-06*WS0' L=1.8e-7
MN_FA01_X1_00A sum01 FA01_X1_ab FA01_X1_n00 0 NM W='1.7999999999999999e-06*WS1' L=1.8e-7
MN_FA01_X1_00B FA01_X1_n00 FA01_X1_bb 0 0 NM W='1.7999999999999999e-06*WS1' L=1.8e-7
MN_FA01_X1_11A sum01 p01 FA01_X1_n11 0 NM W='1.7999999999999999e-06*WS1' L=1.8e-7
MN_FA01_X1_11B FA01_X1_n11 c01 0 0 NM W='1.7999999999999999e-06*WS1' L=1.8e-7
MP_FA01_X1_01A sum01 p01 FA01_X1_p01 vdd PM W='3.5999999999999998e-06*WS1' L=1.8e-7
MP_FA01_X1_01B FA01_X1_p01 FA01_X1_bb vdd vdd PM W='3.5999999999999998e-06*WS1' L=1.8e-7
MP_FA01_X1_10A sum01 FA01_X1_ab FA01_X1_p10 vdd PM W='3.5999999999999998e-06*WS1' L=1.8e-7
MP_FA01_X1_10B FA01_X1_p10 c01 vdd vdd PM W='3.5999999999999998e-06*WS1' L=1.8e-7
MN_FA01_NAB_A nab01 a01 FA01_NAB_mid 0 NM W='2.3999999999999999e-06*WS2' L=1.8e-7
MN_FA01_NAB_B FA01_NAB_mid b01 0 0 NM W='2.3999999999999999e-06*WS2' L=1.8e-7
MP_FA01_NAB_A nab01 a01 vdd vdd PM W='4.7999999999999998e-06*WS2' L=1.8e-7
MP_FA01_NAB_B nab01 b01 vdd vdd PM W='4.7999999999999998e-06*WS2' L=1.8e-7
MN_FA01_NPC_A npc01 p01 FA01_NPC_mid 0 NM W='2.3999999999999999e-06*WS2' L=1.8e-7
MN_FA01_NPC_B FA01_NPC_mid c01 0 0 NM W='2.3999999999999999e-06*WS2' L=1.8e-7
MP_FA01_NPC_A npc01 p01 vdd vdd PM W='4.7999999999999998e-06*WS2' L=1.8e-7
MP_FA01_NPC_B npc01 c01 vdd vdd PM W='4.7999999999999998e-06*WS2' L=1.8e-7
MN_FA01_COUT_A c02 nab01 FA01_COUT_mid 0 NM W='7.9999999999999996e-06*WS3' L=1.8e-7
MN_FA01_COUT_B FA01_COUT_mid npc01 0 0 NM W='7.9999999999999996e-06*WS3' L=1.8e-7
MP_FA01_COUT_A c02 nab01 vdd vdd PM W='1.5999999999999999e-05*WS3' L=1.8e-7
MP_FA01_COUT_B c02 npc01 vdd vdd PM W='1.5999999999999999e-05*WS3' L=1.8e-7
MN_FA02_X0_IA FA02_X0_ab a02 0 0 NM W='1.1999999999999999e-06*WS0' L=1.8e-7
MP_FA02_X0_IA FA02_X0_ab a02 vdd vdd PM W='2.3999999999999999e-06*WS0' L=1.8e-7
MN_FA02_X0_IB FA02_X0_bb b02 0 0 NM W='1.1999999999999999e-06*WS0' L=1.8e-7
MP_FA02_X0_IB FA02_X0_bb b02 vdd vdd PM W='2.3999999999999999e-06*WS0' L=1.8e-7
MN_FA02_X0_00A p02 FA02_X0_ab FA02_X0_n00 0 NM W='1.7999999999999999e-06*WS1' L=1.8e-7
MN_FA02_X0_00B FA02_X0_n00 FA02_X0_bb 0 0 NM W='1.7999999999999999e-06*WS1' L=1.8e-7
MN_FA02_X0_11A p02 a02 FA02_X0_n11 0 NM W='1.7999999999999999e-06*WS1' L=1.8e-7
MN_FA02_X0_11B FA02_X0_n11 b02 0 0 NM W='1.7999999999999999e-06*WS1' L=1.8e-7
MP_FA02_X0_01A p02 a02 FA02_X0_p01 vdd PM W='3.5999999999999998e-06*WS1' L=1.8e-7
MP_FA02_X0_01B FA02_X0_p01 FA02_X0_bb vdd vdd PM W='3.5999999999999998e-06*WS1' L=1.8e-7
MP_FA02_X0_10A p02 FA02_X0_ab FA02_X0_p10 vdd PM W='3.5999999999999998e-06*WS1' L=1.8e-7
MP_FA02_X0_10B FA02_X0_p10 b02 vdd vdd PM W='3.5999999999999998e-06*WS1' L=1.8e-7
MN_FA02_X1_IA FA02_X1_ab p02 0 0 NM W='1.1999999999999999e-06*WS0' L=1.8e-7
MP_FA02_X1_IA FA02_X1_ab p02 vdd vdd PM W='2.3999999999999999e-06*WS0' L=1.8e-7
MN_FA02_X1_IB FA02_X1_bb c02 0 0 NM W='1.1999999999999999e-06*WS0' L=1.8e-7
MP_FA02_X1_IB FA02_X1_bb c02 vdd vdd PM W='2.3999999999999999e-06*WS0' L=1.8e-7
MN_FA02_X1_00A sum02 FA02_X1_ab FA02_X1_n00 0 NM W='1.7999999999999999e-06*WS1' L=1.8e-7
MN_FA02_X1_00B FA02_X1_n00 FA02_X1_bb 0 0 NM W='1.7999999999999999e-06*WS1' L=1.8e-7
MN_FA02_X1_11A sum02 p02 FA02_X1_n11 0 NM W='1.7999999999999999e-06*WS1' L=1.8e-7
MN_FA02_X1_11B FA02_X1_n11 c02 0 0 NM W='1.7999999999999999e-06*WS1' L=1.8e-7
MP_FA02_X1_01A sum02 p02 FA02_X1_p01 vdd PM W='3.5999999999999998e-06*WS1' L=1.8e-7
MP_FA02_X1_01B FA02_X1_p01 FA02_X1_bb vdd vdd PM W='3.5999999999999998e-06*WS1' L=1.8e-7
MP_FA02_X1_10A sum02 FA02_X1_ab FA02_X1_p10 vdd PM W='3.5999999999999998e-06*WS1' L=1.8e-7
MP_FA02_X1_10B FA02_X1_p10 c02 vdd vdd PM W='3.5999999999999998e-06*WS1' L=1.8e-7
MN_FA02_NAB_A nab02 a02 FA02_NAB_mid 0 NM W='2.3999999999999999e-06*WS2' L=1.8e-7
MN_FA02_NAB_B FA02_NAB_mid b02 0 0 NM W='2.3999999999999999e-06*WS2' L=1.8e-7
MP_FA02_NAB_A nab02 a02 vdd vdd PM W='4.7999999999999998e-06*WS2' L=1.8e-7
MP_FA02_NAB_B nab02 b02 vdd vdd PM W='4.7999999999999998e-06*WS2' L=1.8e-7
MN_FA02_NPC_A npc02 p02 FA02_NPC_mid 0 NM W='2.3999999999999999e-06*WS2' L=1.8e-7
MN_FA02_NPC_B FA02_NPC_mid c02 0 0 NM W='2.3999999999999999e-06*WS2' L=1.8e-7
MP_FA02_NPC_A npc02 p02 vdd vdd PM W='4.7999999999999998e-06*WS2' L=1.8e-7
MP_FA02_NPC_B npc02 c02 vdd vdd PM W='4.7999999999999998e-06*WS2' L=1.8e-7
MN_FA02_COUT_A c03 nab02 FA02_COUT_mid 0 NM W='7.9999999999999996e-06*WS3' L=1.8e-7
MN_FA02_COUT_B FA02_COUT_mid npc02 0 0 NM W='7.9999999999999996e-06*WS3' L=1.8e-7
MP_FA02_COUT_A c03 nab02 vdd vdd PM W='1.5999999999999999e-05*WS3' L=1.8e-7
MP_FA02_COUT_B c03 npc02 vdd vdd PM W='1.5999999999999999e-05*WS3' L=1.8e-7
MN_FA03_X0_IA FA03_X0_ab a03 0 0 NM W='1.1999999999999999e-06*WS0' L=1.8e-7
MP_FA03_X0_IA FA03_X0_ab a03 vdd vdd PM W='2.3999999999999999e-06*WS0' L=1.8e-7
MN_FA03_X0_IB FA03_X0_bb b03 0 0 NM W='1.1999999999999999e-06*WS0' L=1.8e-7
MP_FA03_X0_IB FA03_X0_bb b03 vdd vdd PM W='2.3999999999999999e-06*WS0' L=1.8e-7
MN_FA03_X0_00A p03 FA03_X0_ab FA03_X0_n00 0 NM W='1.7999999999999999e-06*WS1' L=1.8e-7
MN_FA03_X0_00B FA03_X0_n00 FA03_X0_bb 0 0 NM W='1.7999999999999999e-06*WS1' L=1.8e-7
MN_FA03_X0_11A p03 a03 FA03_X0_n11 0 NM W='1.7999999999999999e-06*WS1' L=1.8e-7
MN_FA03_X0_11B FA03_X0_n11 b03 0 0 NM W='1.7999999999999999e-06*WS1' L=1.8e-7
MP_FA03_X0_01A p03 a03 FA03_X0_p01 vdd PM W='3.5999999999999998e-06*WS1' L=1.8e-7
MP_FA03_X0_01B FA03_X0_p01 FA03_X0_bb vdd vdd PM W='3.5999999999999998e-06*WS1' L=1.8e-7
MP_FA03_X0_10A p03 FA03_X0_ab FA03_X0_p10 vdd PM W='3.5999999999999998e-06*WS1' L=1.8e-7
MP_FA03_X0_10B FA03_X0_p10 b03 vdd vdd PM W='3.5999999999999998e-06*WS1' L=1.8e-7
MN_FA03_X1_IA FA03_X1_ab p03 0 0 NM W='1.1999999999999999e-06*WS0' L=1.8e-7
MP_FA03_X1_IA FA03_X1_ab p03 vdd vdd PM W='2.3999999999999999e-06*WS0' L=1.8e-7
MN_FA03_X1_IB FA03_X1_bb c03 0 0 NM W='1.1999999999999999e-06*WS0' L=1.8e-7
MP_FA03_X1_IB FA03_X1_bb c03 vdd vdd PM W='2.3999999999999999e-06*WS0' L=1.8e-7
MN_FA03_X1_00A sum03 FA03_X1_ab FA03_X1_n00 0 NM W='1.7999999999999999e-06*WS1' L=1.8e-7
MN_FA03_X1_00B FA03_X1_n00 FA03_X1_bb 0 0 NM W='1.7999999999999999e-06*WS1' L=1.8e-7
MN_FA03_X1_11A sum03 p03 FA03_X1_n11 0 NM W='1.7999999999999999e-06*WS1' L=1.8e-7
MN_FA03_X1_11B FA03_X1_n11 c03 0 0 NM W='1.7999999999999999e-06*WS1' L=1.8e-7
MP_FA03_X1_01A sum03 p03 FA03_X1_p01 vdd PM W='3.5999999999999998e-06*WS1' L=1.8e-7
MP_FA03_X1_01B FA03_X1_p01 FA03_X1_bb vdd vdd PM W='3.5999999999999998e-06*WS1' L=1.8e-7
MP_FA03_X1_10A sum03 FA03_X1_ab FA03_X1_p10 vdd PM W='3.5999999999999998e-06*WS1' L=1.8e-7
MP_FA03_X1_10B FA03_X1_p10 c03 vdd vdd PM W='3.5999999999999998e-06*WS1' L=1.8e-7
MN_FA03_NAB_A nab03 a03 FA03_NAB_mid 0 NM W='2.3999999999999999e-06*WS2' L=1.8e-7
MN_FA03_NAB_B FA03_NAB_mid b03 0 0 NM W='2.3999999999999999e-06*WS2' L=1.8e-7
MP_FA03_NAB_A nab03 a03 vdd vdd PM W='4.7999999999999998e-06*WS2' L=1.8e-7
MP_FA03_NAB_B nab03 b03 vdd vdd PM W='4.7999999999999998e-06*WS2' L=1.8e-7
MN_FA03_NPC_A npc03 p03 FA03_NPC_mid 0 NM W='2.3999999999999999e-06*WS2' L=1.8e-7
MN_FA03_NPC_B FA03_NPC_mid c03 0 0 NM W='2.3999999999999999e-06*WS2' L=1.8e-7
MP_FA03_NPC_A npc03 p03 vdd vdd PM W='4.7999999999999998e-06*WS2' L=1.8e-7
MP_FA03_NPC_B npc03 c03 vdd vdd PM W='4.7999999999999998e-06*WS2' L=1.8e-7
MN_FA03_COUT_A c04 nab03 FA03_COUT_mid 0 NM W='7.9999999999999996e-06*WS3' L=1.8e-7
MN_FA03_COUT_B FA03_COUT_mid npc03 0 0 NM W='7.9999999999999996e-06*WS3' L=1.8e-7
MP_FA03_COUT_A c04 nab03 vdd vdd PM W='1.5999999999999999e-05*WS3' L=1.8e-7
MP_FA03_COUT_B c04 npc03 vdd vdd PM W='1.5999999999999999e-05*WS3' L=1.8e-7
MN_FA04_X0_IA FA04_X0_ab a04 0 0 NM W='1.1999999999999999e-06*WS0' L=1.8e-7
MP_FA04_X0_IA FA04_X0_ab a04 vdd vdd PM W='2.3999999999999999e-06*WS0' L=1.8e-7
MN_FA04_X0_IB FA04_X0_bb b04 0 0 NM W='1.1999999999999999e-06*WS0' L=1.8e-7
MP_FA04_X0_IB FA04_X0_bb b04 vdd vdd PM W='2.3999999999999999e-06*WS0' L=1.8e-7
MN_FA04_X0_00A p04 FA04_X0_ab FA04_X0_n00 0 NM W='1.7999999999999999e-06*WS1' L=1.8e-7
MN_FA04_X0_00B FA04_X0_n00 FA04_X0_bb 0 0 NM W='1.7999999999999999e-06*WS1' L=1.8e-7
MN_FA04_X0_11A p04 a04 FA04_X0_n11 0 NM W='1.7999999999999999e-06*WS1' L=1.8e-7
MN_FA04_X0_11B FA04_X0_n11 b04 0 0 NM W='1.7999999999999999e-06*WS1' L=1.8e-7
MP_FA04_X0_01A p04 a04 FA04_X0_p01 vdd PM W='3.5999999999999998e-06*WS1' L=1.8e-7
MP_FA04_X0_01B FA04_X0_p01 FA04_X0_bb vdd vdd PM W='3.5999999999999998e-06*WS1' L=1.8e-7
MP_FA04_X0_10A p04 FA04_X0_ab FA04_X0_p10 vdd PM W='3.5999999999999998e-06*WS1' L=1.8e-7
MP_FA04_X0_10B FA04_X0_p10 b04 vdd vdd PM W='3.5999999999999998e-06*WS1' L=1.8e-7
MN_FA04_X1_IA FA04_X1_ab p04 0 0 NM W='1.1999999999999999e-06*WS0' L=1.8e-7
MP_FA04_X1_IA FA04_X1_ab p04 vdd vdd PM W='2.3999999999999999e-06*WS0' L=1.8e-7
MN_FA04_X1_IB FA04_X1_bb c04 0 0 NM W='1.1999999999999999e-06*WS0' L=1.8e-7
MP_FA04_X1_IB FA04_X1_bb c04 vdd vdd PM W='2.3999999999999999e-06*WS0' L=1.8e-7
MN_FA04_X1_00A sum04 FA04_X1_ab FA04_X1_n00 0 NM W='1.7999999999999999e-06*WS1' L=1.8e-7
MN_FA04_X1_00B FA04_X1_n00 FA04_X1_bb 0 0 NM W='1.7999999999999999e-06*WS1' L=1.8e-7
MN_FA04_X1_11A sum04 p04 FA04_X1_n11 0 NM W='1.7999999999999999e-06*WS1' L=1.8e-7
MN_FA04_X1_11B FA04_X1_n11 c04 0 0 NM W='1.7999999999999999e-06*WS1' L=1.8e-7
MP_FA04_X1_01A sum04 p04 FA04_X1_p01 vdd PM W='3.5999999999999998e-06*WS1' L=1.8e-7
MP_FA04_X1_01B FA04_X1_p01 FA04_X1_bb vdd vdd PM W='3.5999999999999998e-06*WS1' L=1.8e-7
MP_FA04_X1_10A sum04 FA04_X1_ab FA04_X1_p10 vdd PM W='3.5999999999999998e-06*WS1' L=1.8e-7
MP_FA04_X1_10B FA04_X1_p10 c04 vdd vdd PM W='3.5999999999999998e-06*WS1' L=1.8e-7
MN_FA04_NAB_A nab04 a04 FA04_NAB_mid 0 NM W='2.3999999999999999e-06*WS2' L=1.8e-7
MN_FA04_NAB_B FA04_NAB_mid b04 0 0 NM W='2.3999999999999999e-06*WS2' L=1.8e-7
MP_FA04_NAB_A nab04 a04 vdd vdd PM W='4.7999999999999998e-06*WS2' L=1.8e-7
MP_FA04_NAB_B nab04 b04 vdd vdd PM W='4.7999999999999998e-06*WS2' L=1.8e-7
MN_FA04_NPC_A npc04 p04 FA04_NPC_mid 0 NM W='2.3999999999999999e-06*WS2' L=1.8e-7
MN_FA04_NPC_B FA04_NPC_mid c04 0 0 NM W='2.3999999999999999e-06*WS2' L=1.8e-7
MP_FA04_NPC_A npc04 p04 vdd vdd PM W='4.7999999999999998e-06*WS2' L=1.8e-7
MP_FA04_NPC_B npc04 c04 vdd vdd PM W='4.7999999999999998e-06*WS2' L=1.8e-7
MN_FA04_COUT_A c05 nab04 FA04_COUT_mid 0 NM W='7.9999999999999996e-06*WS3' L=1.8e-7
MN_FA04_COUT_B FA04_COUT_mid npc04 0 0 NM W='7.9999999999999996e-06*WS3' L=1.8e-7
MP_FA04_COUT_A c05 nab04 vdd vdd PM W='1.5999999999999999e-05*WS3' L=1.8e-7
MP_FA04_COUT_B c05 npc04 vdd vdd PM W='1.5999999999999999e-05*WS3' L=1.8e-7
MN_FA05_X0_IA FA05_X0_ab a05 0 0 NM W='1.1999999999999999e-06*WS0' L=1.8e-7
MP_FA05_X0_IA FA05_X0_ab a05 vdd vdd PM W='2.3999999999999999e-06*WS0' L=1.8e-7
MN_FA05_X0_IB FA05_X0_bb b05 0 0 NM W='1.1999999999999999e-06*WS0' L=1.8e-7
MP_FA05_X0_IB FA05_X0_bb b05 vdd vdd PM W='2.3999999999999999e-06*WS0' L=1.8e-7
MN_FA05_X0_00A p05 FA05_X0_ab FA05_X0_n00 0 NM W='1.7999999999999999e-06*WS1' L=1.8e-7
MN_FA05_X0_00B FA05_X0_n00 FA05_X0_bb 0 0 NM W='1.7999999999999999e-06*WS1' L=1.8e-7
MN_FA05_X0_11A p05 a05 FA05_X0_n11 0 NM W='1.7999999999999999e-06*WS1' L=1.8e-7
MN_FA05_X0_11B FA05_X0_n11 b05 0 0 NM W='1.7999999999999999e-06*WS1' L=1.8e-7
MP_FA05_X0_01A p05 a05 FA05_X0_p01 vdd PM W='3.5999999999999998e-06*WS1' L=1.8e-7
MP_FA05_X0_01B FA05_X0_p01 FA05_X0_bb vdd vdd PM W='3.5999999999999998e-06*WS1' L=1.8e-7
MP_FA05_X0_10A p05 FA05_X0_ab FA05_X0_p10 vdd PM W='3.5999999999999998e-06*WS1' L=1.8e-7
MP_FA05_X0_10B FA05_X0_p10 b05 vdd vdd PM W='3.5999999999999998e-06*WS1' L=1.8e-7
MN_FA05_X1_IA FA05_X1_ab p05 0 0 NM W='1.1999999999999999e-06*WS0' L=1.8e-7
MP_FA05_X1_IA FA05_X1_ab p05 vdd vdd PM W='2.3999999999999999e-06*WS0' L=1.8e-7
MN_FA05_X1_IB FA05_X1_bb c05 0 0 NM W='1.1999999999999999e-06*WS0' L=1.8e-7
MP_FA05_X1_IB FA05_X1_bb c05 vdd vdd PM W='2.3999999999999999e-06*WS0' L=1.8e-7
MN_FA05_X1_00A sum05 FA05_X1_ab FA05_X1_n00 0 NM W='1.7999999999999999e-06*WS1' L=1.8e-7
MN_FA05_X1_00B FA05_X1_n00 FA05_X1_bb 0 0 NM W='1.7999999999999999e-06*WS1' L=1.8e-7
MN_FA05_X1_11A sum05 p05 FA05_X1_n11 0 NM W='1.7999999999999999e-06*WS1' L=1.8e-7
MN_FA05_X1_11B FA05_X1_n11 c05 0 0 NM W='1.7999999999999999e-06*WS1' L=1.8e-7
MP_FA05_X1_01A sum05 p05 FA05_X1_p01 vdd PM W='3.5999999999999998e-06*WS1' L=1.8e-7
MP_FA05_X1_01B FA05_X1_p01 FA05_X1_bb vdd vdd PM W='3.5999999999999998e-06*WS1' L=1.8e-7
MP_FA05_X1_10A sum05 FA05_X1_ab FA05_X1_p10 vdd PM W='3.5999999999999998e-06*WS1' L=1.8e-7
MP_FA05_X1_10B FA05_X1_p10 c05 vdd vdd PM W='3.5999999999999998e-06*WS1' L=1.8e-7
MN_FA05_NAB_A nab05 a05 FA05_NAB_mid 0 NM W='2.3999999999999999e-06*WS2' L=1.8e-7
MN_FA05_NAB_B FA05_NAB_mid b05 0 0 NM W='2.3999999999999999e-06*WS2' L=1.8e-7
MP_FA05_NAB_A nab05 a05 vdd vdd PM W='4.7999999999999998e-06*WS2' L=1.8e-7
MP_FA05_NAB_B nab05 b05 vdd vdd PM W='4.7999999999999998e-06*WS2' L=1.8e-7
MN_FA05_NPC_A npc05 p05 FA05_NPC_mid 0 NM W='2.3999999999999999e-06*WS2' L=1.8e-7
MN_FA05_NPC_B FA05_NPC_mid c05 0 0 NM W='2.3999999999999999e-06*WS2' L=1.8e-7
MP_FA05_NPC_A npc05 p05 vdd vdd PM W='4.7999999999999998e-06*WS2' L=1.8e-7
MP_FA05_NPC_B npc05 c05 vdd vdd PM W='4.7999999999999998e-06*WS2' L=1.8e-7
MN_FA05_COUT_A c06 nab05 FA05_COUT_mid 0 NM W='7.9999999999999996e-06*WS3' L=1.8e-7
MN_FA05_COUT_B FA05_COUT_mid npc05 0 0 NM W='7.9999999999999996e-06*WS3' L=1.8e-7
MP_FA05_COUT_A c06 nab05 vdd vdd PM W='1.5999999999999999e-05*WS3' L=1.8e-7
MP_FA05_COUT_B c06 npc05 vdd vdd PM W='1.5999999999999999e-05*WS3' L=1.8e-7
MN_FA06_X0_IA FA06_X0_ab a06 0 0 NM W='1.1999999999999999e-06*WS0' L=1.8e-7
MP_FA06_X0_IA FA06_X0_ab a06 vdd vdd PM W='2.3999999999999999e-06*WS0' L=1.8e-7
MN_FA06_X0_IB FA06_X0_bb b06 0 0 NM W='1.1999999999999999e-06*WS0' L=1.8e-7
MP_FA06_X0_IB FA06_X0_bb b06 vdd vdd PM W='2.3999999999999999e-06*WS0' L=1.8e-7
MN_FA06_X0_00A p06 FA06_X0_ab FA06_X0_n00 0 NM W='1.7999999999999999e-06*WS1' L=1.8e-7
MN_FA06_X0_00B FA06_X0_n00 FA06_X0_bb 0 0 NM W='1.7999999999999999e-06*WS1' L=1.8e-7
MN_FA06_X0_11A p06 a06 FA06_X0_n11 0 NM W='1.7999999999999999e-06*WS1' L=1.8e-7
MN_FA06_X0_11B FA06_X0_n11 b06 0 0 NM W='1.7999999999999999e-06*WS1' L=1.8e-7
MP_FA06_X0_01A p06 a06 FA06_X0_p01 vdd PM W='3.5999999999999998e-06*WS1' L=1.8e-7
MP_FA06_X0_01B FA06_X0_p01 FA06_X0_bb vdd vdd PM W='3.5999999999999998e-06*WS1' L=1.8e-7
MP_FA06_X0_10A p06 FA06_X0_ab FA06_X0_p10 vdd PM W='3.5999999999999998e-06*WS1' L=1.8e-7
MP_FA06_X0_10B FA06_X0_p10 b06 vdd vdd PM W='3.5999999999999998e-06*WS1' L=1.8e-7
MN_FA06_X1_IA FA06_X1_ab p06 0 0 NM W='1.1999999999999999e-06*WS0' L=1.8e-7
MP_FA06_X1_IA FA06_X1_ab p06 vdd vdd PM W='2.3999999999999999e-06*WS0' L=1.8e-7
MN_FA06_X1_IB FA06_X1_bb c06 0 0 NM W='1.1999999999999999e-06*WS0' L=1.8e-7
MP_FA06_X1_IB FA06_X1_bb c06 vdd vdd PM W='2.3999999999999999e-06*WS0' L=1.8e-7
MN_FA06_X1_00A sum06 FA06_X1_ab FA06_X1_n00 0 NM W='1.7999999999999999e-06*WS1' L=1.8e-7
MN_FA06_X1_00B FA06_X1_n00 FA06_X1_bb 0 0 NM W='1.7999999999999999e-06*WS1' L=1.8e-7
MN_FA06_X1_11A sum06 p06 FA06_X1_n11 0 NM W='1.7999999999999999e-06*WS1' L=1.8e-7
MN_FA06_X1_11B FA06_X1_n11 c06 0 0 NM W='1.7999999999999999e-06*WS1' L=1.8e-7
MP_FA06_X1_01A sum06 p06 FA06_X1_p01 vdd PM W='3.5999999999999998e-06*WS1' L=1.8e-7
MP_FA06_X1_01B FA06_X1_p01 FA06_X1_bb vdd vdd PM W='3.5999999999999998e-06*WS1' L=1.8e-7
MP_FA06_X1_10A sum06 FA06_X1_ab FA06_X1_p10 vdd PM W='3.5999999999999998e-06*WS1' L=1.8e-7
MP_FA06_X1_10B FA06_X1_p10 c06 vdd vdd PM W='3.5999999999999998e-06*WS1' L=1.8e-7
MN_FA06_NAB_A nab06 a06 FA06_NAB_mid 0 NM W='2.3999999999999999e-06*WS2' L=1.8e-7
MN_FA06_NAB_B FA06_NAB_mid b06 0 0 NM W='2.3999999999999999e-06*WS2' L=1.8e-7
MP_FA06_NAB_A nab06 a06 vdd vdd PM W='4.7999999999999998e-06*WS2' L=1.8e-7
MP_FA06_NAB_B nab06 b06 vdd vdd PM W='4.7999999999999998e-06*WS2' L=1.8e-7
MN_FA06_NPC_A npc06 p06 FA06_NPC_mid 0 NM W='2.3999999999999999e-06*WS2' L=1.8e-7
MN_FA06_NPC_B FA06_NPC_mid c06 0 0 NM W='2.3999999999999999e-06*WS2' L=1.8e-7
MP_FA06_NPC_A npc06 p06 vdd vdd PM W='4.7999999999999998e-06*WS2' L=1.8e-7
MP_FA06_NPC_B npc06 c06 vdd vdd PM W='4.7999999999999998e-06*WS2' L=1.8e-7
MN_FA06_COUT_A c07 nab06 FA06_COUT_mid 0 NM W='7.9999999999999996e-06*WS3' L=1.8e-7
MN_FA06_COUT_B FA06_COUT_mid npc06 0 0 NM W='7.9999999999999996e-06*WS3' L=1.8e-7
MP_FA06_COUT_A c07 nab06 vdd vdd PM W='1.5999999999999999e-05*WS3' L=1.8e-7
MP_FA06_COUT_B c07 npc06 vdd vdd PM W='1.5999999999999999e-05*WS3' L=1.8e-7
MN_FA07_X0_IA FA07_X0_ab a07 0 0 NM W='1.1999999999999999e-06*WS0' L=1.8e-7
MP_FA07_X0_IA FA07_X0_ab a07 vdd vdd PM W='2.3999999999999999e-06*WS0' L=1.8e-7
MN_FA07_X0_IB FA07_X0_bb b07 0 0 NM W='1.1999999999999999e-06*WS0' L=1.8e-7
MP_FA07_X0_IB FA07_X0_bb b07 vdd vdd PM W='2.3999999999999999e-06*WS0' L=1.8e-7
MN_FA07_X0_00A p07 FA07_X0_ab FA07_X0_n00 0 NM W='1.7999999999999999e-06*WS1' L=1.8e-7
MN_FA07_X0_00B FA07_X0_n00 FA07_X0_bb 0 0 NM W='1.7999999999999999e-06*WS1' L=1.8e-7
MN_FA07_X0_11A p07 a07 FA07_X0_n11 0 NM W='1.7999999999999999e-06*WS1' L=1.8e-7
MN_FA07_X0_11B FA07_X0_n11 b07 0 0 NM W='1.7999999999999999e-06*WS1' L=1.8e-7
MP_FA07_X0_01A p07 a07 FA07_X0_p01 vdd PM W='3.5999999999999998e-06*WS1' L=1.8e-7
MP_FA07_X0_01B FA07_X0_p01 FA07_X0_bb vdd vdd PM W='3.5999999999999998e-06*WS1' L=1.8e-7
MP_FA07_X0_10A p07 FA07_X0_ab FA07_X0_p10 vdd PM W='3.5999999999999998e-06*WS1' L=1.8e-7
MP_FA07_X0_10B FA07_X0_p10 b07 vdd vdd PM W='3.5999999999999998e-06*WS1' L=1.8e-7
MN_FA07_X1_IA FA07_X1_ab p07 0 0 NM W='1.1999999999999999e-06*WS0' L=1.8e-7
MP_FA07_X1_IA FA07_X1_ab p07 vdd vdd PM W='2.3999999999999999e-06*WS0' L=1.8e-7
MN_FA07_X1_IB FA07_X1_bb c07 0 0 NM W='1.1999999999999999e-06*WS0' L=1.8e-7
MP_FA07_X1_IB FA07_X1_bb c07 vdd vdd PM W='2.3999999999999999e-06*WS0' L=1.8e-7
MN_FA07_X1_00A sum07 FA07_X1_ab FA07_X1_n00 0 NM W='1.7999999999999999e-06*WS1' L=1.8e-7
MN_FA07_X1_00B FA07_X1_n00 FA07_X1_bb 0 0 NM W='1.7999999999999999e-06*WS1' L=1.8e-7
MN_FA07_X1_11A sum07 p07 FA07_X1_n11 0 NM W='1.7999999999999999e-06*WS1' L=1.8e-7
MN_FA07_X1_11B FA07_X1_n11 c07 0 0 NM W='1.7999999999999999e-06*WS1' L=1.8e-7
MP_FA07_X1_01A sum07 p07 FA07_X1_p01 vdd PM W='3.5999999999999998e-06*WS1' L=1.8e-7
MP_FA07_X1_01B FA07_X1_p01 FA07_X1_bb vdd vdd PM W='3.5999999999999998e-06*WS1' L=1.8e-7
MP_FA07_X1_10A sum07 FA07_X1_ab FA07_X1_p10 vdd PM W='3.5999999999999998e-06*WS1' L=1.8e-7
MP_FA07_X1_10B FA07_X1_p10 c07 vdd vdd PM W='3.5999999999999998e-06*WS1' L=1.8e-7
MN_FA07_NAB_A nab07 a07 FA07_NAB_mid 0 NM W='2.3999999999999999e-06*WS2' L=1.8e-7
MN_FA07_NAB_B FA07_NAB_mid b07 0 0 NM W='2.3999999999999999e-06*WS2' L=1.8e-7
MP_FA07_NAB_A nab07 a07 vdd vdd PM W='4.7999999999999998e-06*WS2' L=1.8e-7
MP_FA07_NAB_B nab07 b07 vdd vdd PM W='4.7999999999999998e-06*WS2' L=1.8e-7
MN_FA07_NPC_A npc07 p07 FA07_NPC_mid 0 NM W='2.3999999999999999e-06*WS2' L=1.8e-7
MN_FA07_NPC_B FA07_NPC_mid c07 0 0 NM W='2.3999999999999999e-06*WS2' L=1.8e-7
MP_FA07_NPC_A npc07 p07 vdd vdd PM W='4.7999999999999998e-06*WS2' L=1.8e-7
MP_FA07_NPC_B npc07 c07 vdd vdd PM W='4.7999999999999998e-06*WS2' L=1.8e-7
MN_FA07_COUT_A c08 nab07 FA07_COUT_mid 0 NM W='7.9999999999999996e-06*WS3' L=1.8e-7
MN_FA07_COUT_B FA07_COUT_mid npc07 0 0 NM W='7.9999999999999996e-06*WS3' L=1.8e-7
MP_FA07_COUT_A c08 nab07 vdd vdd PM W='1.5999999999999999e-05*WS3' L=1.8e-7
MP_FA07_COUT_B c08 npc07 vdd vdd PM W='1.5999999999999999e-05*WS3' L=1.8e-7
MN_FA08_X0_IA FA08_X0_ab a08 0 0 NM W='1.1999999999999999e-06*WS0' L=1.8e-7
MP_FA08_X0_IA FA08_X0_ab a08 vdd vdd PM W='2.3999999999999999e-06*WS0' L=1.8e-7
MN_FA08_X0_IB FA08_X0_bb b08 0 0 NM W='1.1999999999999999e-06*WS0' L=1.8e-7
MP_FA08_X0_IB FA08_X0_bb b08 vdd vdd PM W='2.3999999999999999e-06*WS0' L=1.8e-7
MN_FA08_X0_00A p08 FA08_X0_ab FA08_X0_n00 0 NM W='1.7999999999999999e-06*WS1' L=1.8e-7
MN_FA08_X0_00B FA08_X0_n00 FA08_X0_bb 0 0 NM W='1.7999999999999999e-06*WS1' L=1.8e-7
MN_FA08_X0_11A p08 a08 FA08_X0_n11 0 NM W='1.7999999999999999e-06*WS1' L=1.8e-7
MN_FA08_X0_11B FA08_X0_n11 b08 0 0 NM W='1.7999999999999999e-06*WS1' L=1.8e-7
MP_FA08_X0_01A p08 a08 FA08_X0_p01 vdd PM W='3.5999999999999998e-06*WS1' L=1.8e-7
MP_FA08_X0_01B FA08_X0_p01 FA08_X0_bb vdd vdd PM W='3.5999999999999998e-06*WS1' L=1.8e-7
MP_FA08_X0_10A p08 FA08_X0_ab FA08_X0_p10 vdd PM W='3.5999999999999998e-06*WS1' L=1.8e-7
MP_FA08_X0_10B FA08_X0_p10 b08 vdd vdd PM W='3.5999999999999998e-06*WS1' L=1.8e-7
MN_FA08_X1_IA FA08_X1_ab p08 0 0 NM W='1.1999999999999999e-06*WS0' L=1.8e-7
MP_FA08_X1_IA FA08_X1_ab p08 vdd vdd PM W='2.3999999999999999e-06*WS0' L=1.8e-7
MN_FA08_X1_IB FA08_X1_bb c08 0 0 NM W='1.1999999999999999e-06*WS0' L=1.8e-7
MP_FA08_X1_IB FA08_X1_bb c08 vdd vdd PM W='2.3999999999999999e-06*WS0' L=1.8e-7
MN_FA08_X1_00A sum08 FA08_X1_ab FA08_X1_n00 0 NM W='1.7999999999999999e-06*WS1' L=1.8e-7
MN_FA08_X1_00B FA08_X1_n00 FA08_X1_bb 0 0 NM W='1.7999999999999999e-06*WS1' L=1.8e-7
MN_FA08_X1_11A sum08 p08 FA08_X1_n11 0 NM W='1.7999999999999999e-06*WS1' L=1.8e-7
MN_FA08_X1_11B FA08_X1_n11 c08 0 0 NM W='1.7999999999999999e-06*WS1' L=1.8e-7
MP_FA08_X1_01A sum08 p08 FA08_X1_p01 vdd PM W='3.5999999999999998e-06*WS1' L=1.8e-7
MP_FA08_X1_01B FA08_X1_p01 FA08_X1_bb vdd vdd PM W='3.5999999999999998e-06*WS1' L=1.8e-7
MP_FA08_X1_10A sum08 FA08_X1_ab FA08_X1_p10 vdd PM W='3.5999999999999998e-06*WS1' L=1.8e-7
MP_FA08_X1_10B FA08_X1_p10 c08 vdd vdd PM W='3.5999999999999998e-06*WS1' L=1.8e-7
MN_FA08_NAB_A nab08 a08 FA08_NAB_mid 0 NM W='2.3999999999999999e-06*WS2' L=1.8e-7
MN_FA08_NAB_B FA08_NAB_mid b08 0 0 NM W='2.3999999999999999e-06*WS2' L=1.8e-7
MP_FA08_NAB_A nab08 a08 vdd vdd PM W='4.7999999999999998e-06*WS2' L=1.8e-7
MP_FA08_NAB_B nab08 b08 vdd vdd PM W='4.7999999999999998e-06*WS2' L=1.8e-7
MN_FA08_NPC_A npc08 p08 FA08_NPC_mid 0 NM W='2.3999999999999999e-06*WS2' L=1.8e-7
MN_FA08_NPC_B FA08_NPC_mid c08 0 0 NM W='2.3999999999999999e-06*WS2' L=1.8e-7
MP_FA08_NPC_A npc08 p08 vdd vdd PM W='4.7999999999999998e-06*WS2' L=1.8e-7
MP_FA08_NPC_B npc08 c08 vdd vdd PM W='4.7999999999999998e-06*WS2' L=1.8e-7
MN_FA08_COUT_A c09 nab08 FA08_COUT_mid 0 NM W='7.9999999999999996e-06*WS3' L=1.8e-7
MN_FA08_COUT_B FA08_COUT_mid npc08 0 0 NM W='7.9999999999999996e-06*WS3' L=1.8e-7
MP_FA08_COUT_A c09 nab08 vdd vdd PM W='1.5999999999999999e-05*WS3' L=1.8e-7
MP_FA08_COUT_B c09 npc08 vdd vdd PM W='1.5999999999999999e-05*WS3' L=1.8e-7
MN_FA09_X0_IA FA09_X0_ab a09 0 0 NM W='1.1999999999999999e-06*WS0' L=1.8e-7
MP_FA09_X0_IA FA09_X0_ab a09 vdd vdd PM W='2.3999999999999999e-06*WS0' L=1.8e-7
MN_FA09_X0_IB FA09_X0_bb b09 0 0 NM W='1.1999999999999999e-06*WS0' L=1.8e-7
MP_FA09_X0_IB FA09_X0_bb b09 vdd vdd PM W='2.3999999999999999e-06*WS0' L=1.8e-7
MN_FA09_X0_00A p09 FA09_X0_ab FA09_X0_n00 0 NM W='1.7999999999999999e-06*WS1' L=1.8e-7
MN_FA09_X0_00B FA09_X0_n00 FA09_X0_bb 0 0 NM W='1.7999999999999999e-06*WS1' L=1.8e-7
MN_FA09_X0_11A p09 a09 FA09_X0_n11 0 NM W='1.7999999999999999e-06*WS1' L=1.8e-7
MN_FA09_X0_11B FA09_X0_n11 b09 0 0 NM W='1.7999999999999999e-06*WS1' L=1.8e-7
MP_FA09_X0_01A p09 a09 FA09_X0_p01 vdd PM W='3.5999999999999998e-06*WS1' L=1.8e-7
MP_FA09_X0_01B FA09_X0_p01 FA09_X0_bb vdd vdd PM W='3.5999999999999998e-06*WS1' L=1.8e-7
MP_FA09_X0_10A p09 FA09_X0_ab FA09_X0_p10 vdd PM W='3.5999999999999998e-06*WS1' L=1.8e-7
MP_FA09_X0_10B FA09_X0_p10 b09 vdd vdd PM W='3.5999999999999998e-06*WS1' L=1.8e-7
MN_FA09_X1_IA FA09_X1_ab p09 0 0 NM W='1.1999999999999999e-06*WS0' L=1.8e-7
MP_FA09_X1_IA FA09_X1_ab p09 vdd vdd PM W='2.3999999999999999e-06*WS0' L=1.8e-7
MN_FA09_X1_IB FA09_X1_bb c09 0 0 NM W='1.1999999999999999e-06*WS0' L=1.8e-7
MP_FA09_X1_IB FA09_X1_bb c09 vdd vdd PM W='2.3999999999999999e-06*WS0' L=1.8e-7
MN_FA09_X1_00A sum09 FA09_X1_ab FA09_X1_n00 0 NM W='1.7999999999999999e-06*WS1' L=1.8e-7
MN_FA09_X1_00B FA09_X1_n00 FA09_X1_bb 0 0 NM W='1.7999999999999999e-06*WS1' L=1.8e-7
MN_FA09_X1_11A sum09 p09 FA09_X1_n11 0 NM W='1.7999999999999999e-06*WS1' L=1.8e-7
MN_FA09_X1_11B FA09_X1_n11 c09 0 0 NM W='1.7999999999999999e-06*WS1' L=1.8e-7
MP_FA09_X1_01A sum09 p09 FA09_X1_p01 vdd PM W='3.5999999999999998e-06*WS1' L=1.8e-7
MP_FA09_X1_01B FA09_X1_p01 FA09_X1_bb vdd vdd PM W='3.5999999999999998e-06*WS1' L=1.8e-7
MP_FA09_X1_10A sum09 FA09_X1_ab FA09_X1_p10 vdd PM W='3.5999999999999998e-06*WS1' L=1.8e-7
MP_FA09_X1_10B FA09_X1_p10 c09 vdd vdd PM W='3.5999999999999998e-06*WS1' L=1.8e-7
MN_FA09_NAB_A nab09 a09 FA09_NAB_mid 0 NM W='2.3999999999999999e-06*WS2' L=1.8e-7
MN_FA09_NAB_B FA09_NAB_mid b09 0 0 NM W='2.3999999999999999e-06*WS2' L=1.8e-7
MP_FA09_NAB_A nab09 a09 vdd vdd PM W='4.7999999999999998e-06*WS2' L=1.8e-7
MP_FA09_NAB_B nab09 b09 vdd vdd PM W='4.7999999999999998e-06*WS2' L=1.8e-7
MN_FA09_NPC_A npc09 p09 FA09_NPC_mid 0 NM W='2.3999999999999999e-06*WS2' L=1.8e-7
MN_FA09_NPC_B FA09_NPC_mid c09 0 0 NM W='2.3999999999999999e-06*WS2' L=1.8e-7
MP_FA09_NPC_A npc09 p09 vdd vdd PM W='4.7999999999999998e-06*WS2' L=1.8e-7
MP_FA09_NPC_B npc09 c09 vdd vdd PM W='4.7999999999999998e-06*WS2' L=1.8e-7
MN_FA09_COUT_A c10 nab09 FA09_COUT_mid 0 NM W='7.9999999999999996e-06*WS3' L=1.8e-7
MN_FA09_COUT_B FA09_COUT_mid npc09 0 0 NM W='7.9999999999999996e-06*WS3' L=1.8e-7
MP_FA09_COUT_A c10 nab09 vdd vdd PM W='1.5999999999999999e-05*WS3' L=1.8e-7
MP_FA09_COUT_B c10 npc09 vdd vdd PM W='1.5999999999999999e-05*WS3' L=1.8e-7
MN_FA10_X0_IA FA10_X0_ab a10 0 0 NM W='1.1999999999999999e-06*WS0' L=1.8e-7
MP_FA10_X0_IA FA10_X0_ab a10 vdd vdd PM W='2.3999999999999999e-06*WS0' L=1.8e-7
MN_FA10_X0_IB FA10_X0_bb b10 0 0 NM W='1.1999999999999999e-06*WS0' L=1.8e-7
MP_FA10_X0_IB FA10_X0_bb b10 vdd vdd PM W='2.3999999999999999e-06*WS0' L=1.8e-7
MN_FA10_X0_00A p10 FA10_X0_ab FA10_X0_n00 0 NM W='1.7999999999999999e-06*WS1' L=1.8e-7
MN_FA10_X0_00B FA10_X0_n00 FA10_X0_bb 0 0 NM W='1.7999999999999999e-06*WS1' L=1.8e-7
MN_FA10_X0_11A p10 a10 FA10_X0_n11 0 NM W='1.7999999999999999e-06*WS1' L=1.8e-7
MN_FA10_X0_11B FA10_X0_n11 b10 0 0 NM W='1.7999999999999999e-06*WS1' L=1.8e-7
MP_FA10_X0_01A p10 a10 FA10_X0_p01 vdd PM W='3.5999999999999998e-06*WS1' L=1.8e-7
MP_FA10_X0_01B FA10_X0_p01 FA10_X0_bb vdd vdd PM W='3.5999999999999998e-06*WS1' L=1.8e-7
MP_FA10_X0_10A p10 FA10_X0_ab FA10_X0_p10 vdd PM W='3.5999999999999998e-06*WS1' L=1.8e-7
MP_FA10_X0_10B FA10_X0_p10 b10 vdd vdd PM W='3.5999999999999998e-06*WS1' L=1.8e-7
MN_FA10_X1_IA FA10_X1_ab p10 0 0 NM W='1.1999999999999999e-06*WS0' L=1.8e-7
MP_FA10_X1_IA FA10_X1_ab p10 vdd vdd PM W='2.3999999999999999e-06*WS0' L=1.8e-7
MN_FA10_X1_IB FA10_X1_bb c10 0 0 NM W='1.1999999999999999e-06*WS0' L=1.8e-7
MP_FA10_X1_IB FA10_X1_bb c10 vdd vdd PM W='2.3999999999999999e-06*WS0' L=1.8e-7
MN_FA10_X1_00A sum10 FA10_X1_ab FA10_X1_n00 0 NM W='1.7999999999999999e-06*WS1' L=1.8e-7
MN_FA10_X1_00B FA10_X1_n00 FA10_X1_bb 0 0 NM W='1.7999999999999999e-06*WS1' L=1.8e-7
MN_FA10_X1_11A sum10 p10 FA10_X1_n11 0 NM W='1.7999999999999999e-06*WS1' L=1.8e-7
MN_FA10_X1_11B FA10_X1_n11 c10 0 0 NM W='1.7999999999999999e-06*WS1' L=1.8e-7
MP_FA10_X1_01A sum10 p10 FA10_X1_p01 vdd PM W='3.5999999999999998e-06*WS1' L=1.8e-7
MP_FA10_X1_01B FA10_X1_p01 FA10_X1_bb vdd vdd PM W='3.5999999999999998e-06*WS1' L=1.8e-7
MP_FA10_X1_10A sum10 FA10_X1_ab FA10_X1_p10 vdd PM W='3.5999999999999998e-06*WS1' L=1.8e-7
MP_FA10_X1_10B FA10_X1_p10 c10 vdd vdd PM W='3.5999999999999998e-06*WS1' L=1.8e-7
MN_FA10_NAB_A nab10 a10 FA10_NAB_mid 0 NM W='2.3999999999999999e-06*WS2' L=1.8e-7
MN_FA10_NAB_B FA10_NAB_mid b10 0 0 NM W='2.3999999999999999e-06*WS2' L=1.8e-7
MP_FA10_NAB_A nab10 a10 vdd vdd PM W='4.7999999999999998e-06*WS2' L=1.8e-7
MP_FA10_NAB_B nab10 b10 vdd vdd PM W='4.7999999999999998e-06*WS2' L=1.8e-7
MN_FA10_NPC_A npc10 p10 FA10_NPC_mid 0 NM W='2.3999999999999999e-06*WS2' L=1.8e-7
MN_FA10_NPC_B FA10_NPC_mid c10 0 0 NM W='2.3999999999999999e-06*WS2' L=1.8e-7
MP_FA10_NPC_A npc10 p10 vdd vdd PM W='4.7999999999999998e-06*WS2' L=1.8e-7
MP_FA10_NPC_B npc10 c10 vdd vdd PM W='4.7999999999999998e-06*WS2' L=1.8e-7
MN_FA10_COUT_A c11 nab10 FA10_COUT_mid 0 NM W='7.9999999999999996e-06*WS3' L=1.8e-7
MN_FA10_COUT_B FA10_COUT_mid npc10 0 0 NM W='7.9999999999999996e-06*WS3' L=1.8e-7
MP_FA10_COUT_A c11 nab10 vdd vdd PM W='1.5999999999999999e-05*WS3' L=1.8e-7
MP_FA10_COUT_B c11 npc10 vdd vdd PM W='1.5999999999999999e-05*WS3' L=1.8e-7
MN_FA11_X0_IA FA11_X0_ab a11 0 0 NM W='1.1999999999999999e-06*WS0' L=1.8e-7
MP_FA11_X0_IA FA11_X0_ab a11 vdd vdd PM W='2.3999999999999999e-06*WS0' L=1.8e-7
MN_FA11_X0_IB FA11_X0_bb b11 0 0 NM W='1.1999999999999999e-06*WS0' L=1.8e-7
MP_FA11_X0_IB FA11_X0_bb b11 vdd vdd PM W='2.3999999999999999e-06*WS0' L=1.8e-7
MN_FA11_X0_00A p11 FA11_X0_ab FA11_X0_n00 0 NM W='1.7999999999999999e-06*WS1' L=1.8e-7
MN_FA11_X0_00B FA11_X0_n00 FA11_X0_bb 0 0 NM W='1.7999999999999999e-06*WS1' L=1.8e-7
MN_FA11_X0_11A p11 a11 FA11_X0_n11 0 NM W='1.7999999999999999e-06*WS1' L=1.8e-7
MN_FA11_X0_11B FA11_X0_n11 b11 0 0 NM W='1.7999999999999999e-06*WS1' L=1.8e-7
MP_FA11_X0_01A p11 a11 FA11_X0_p01 vdd PM W='3.5999999999999998e-06*WS1' L=1.8e-7
MP_FA11_X0_01B FA11_X0_p01 FA11_X0_bb vdd vdd PM W='3.5999999999999998e-06*WS1' L=1.8e-7
MP_FA11_X0_10A p11 FA11_X0_ab FA11_X0_p10 vdd PM W='3.5999999999999998e-06*WS1' L=1.8e-7
MP_FA11_X0_10B FA11_X0_p10 b11 vdd vdd PM W='3.5999999999999998e-06*WS1' L=1.8e-7
MN_FA11_X1_IA FA11_X1_ab p11 0 0 NM W='1.1999999999999999e-06*WS0' L=1.8e-7
MP_FA11_X1_IA FA11_X1_ab p11 vdd vdd PM W='2.3999999999999999e-06*WS0' L=1.8e-7
MN_FA11_X1_IB FA11_X1_bb c11 0 0 NM W='1.1999999999999999e-06*WS0' L=1.8e-7
MP_FA11_X1_IB FA11_X1_bb c11 vdd vdd PM W='2.3999999999999999e-06*WS0' L=1.8e-7
MN_FA11_X1_00A sum11 FA11_X1_ab FA11_X1_n00 0 NM W='1.7999999999999999e-06*WS1' L=1.8e-7
MN_FA11_X1_00B FA11_X1_n00 FA11_X1_bb 0 0 NM W='1.7999999999999999e-06*WS1' L=1.8e-7
MN_FA11_X1_11A sum11 p11 FA11_X1_n11 0 NM W='1.7999999999999999e-06*WS1' L=1.8e-7
MN_FA11_X1_11B FA11_X1_n11 c11 0 0 NM W='1.7999999999999999e-06*WS1' L=1.8e-7
MP_FA11_X1_01A sum11 p11 FA11_X1_p01 vdd PM W='3.5999999999999998e-06*WS1' L=1.8e-7
MP_FA11_X1_01B FA11_X1_p01 FA11_X1_bb vdd vdd PM W='3.5999999999999998e-06*WS1' L=1.8e-7
MP_FA11_X1_10A sum11 FA11_X1_ab FA11_X1_p10 vdd PM W='3.5999999999999998e-06*WS1' L=1.8e-7
MP_FA11_X1_10B FA11_X1_p10 c11 vdd vdd PM W='3.5999999999999998e-06*WS1' L=1.8e-7
MN_FA11_NAB_A nab11 a11 FA11_NAB_mid 0 NM W='2.3999999999999999e-06*WS2' L=1.8e-7
MN_FA11_NAB_B FA11_NAB_mid b11 0 0 NM W='2.3999999999999999e-06*WS2' L=1.8e-7
MP_FA11_NAB_A nab11 a11 vdd vdd PM W='4.7999999999999998e-06*WS2' L=1.8e-7
MP_FA11_NAB_B nab11 b11 vdd vdd PM W='4.7999999999999998e-06*WS2' L=1.8e-7
MN_FA11_NPC_A npc11 p11 FA11_NPC_mid 0 NM W='2.3999999999999999e-06*WS2' L=1.8e-7
MN_FA11_NPC_B FA11_NPC_mid c11 0 0 NM W='2.3999999999999999e-06*WS2' L=1.8e-7
MP_FA11_NPC_A npc11 p11 vdd vdd PM W='4.7999999999999998e-06*WS2' L=1.8e-7
MP_FA11_NPC_B npc11 c11 vdd vdd PM W='4.7999999999999998e-06*WS2' L=1.8e-7
MN_FA11_COUT_A c12 nab11 FA11_COUT_mid 0 NM W='7.9999999999999996e-06*WS3' L=1.8e-7
MN_FA11_COUT_B FA11_COUT_mid npc11 0 0 NM W='7.9999999999999996e-06*WS3' L=1.8e-7
MP_FA11_COUT_A c12 nab11 vdd vdd PM W='1.5999999999999999e-05*WS3' L=1.8e-7
MP_FA11_COUT_B c12 npc11 vdd vdd PM W='1.5999999999999999e-05*WS3' L=1.8e-7
MN_FA12_X0_IA FA12_X0_ab a12 0 0 NM W='1.1999999999999999e-06*WS0' L=1.8e-7
MP_FA12_X0_IA FA12_X0_ab a12 vdd vdd PM W='2.3999999999999999e-06*WS0' L=1.8e-7
MN_FA12_X0_IB FA12_X0_bb b12 0 0 NM W='1.1999999999999999e-06*WS0' L=1.8e-7
MP_FA12_X0_IB FA12_X0_bb b12 vdd vdd PM W='2.3999999999999999e-06*WS0' L=1.8e-7
MN_FA12_X0_00A p12 FA12_X0_ab FA12_X0_n00 0 NM W='1.7999999999999999e-06*WS1' L=1.8e-7
MN_FA12_X0_00B FA12_X0_n00 FA12_X0_bb 0 0 NM W='1.7999999999999999e-06*WS1' L=1.8e-7
MN_FA12_X0_11A p12 a12 FA12_X0_n11 0 NM W='1.7999999999999999e-06*WS1' L=1.8e-7
MN_FA12_X0_11B FA12_X0_n11 b12 0 0 NM W='1.7999999999999999e-06*WS1' L=1.8e-7
MP_FA12_X0_01A p12 a12 FA12_X0_p01 vdd PM W='3.5999999999999998e-06*WS1' L=1.8e-7
MP_FA12_X0_01B FA12_X0_p01 FA12_X0_bb vdd vdd PM W='3.5999999999999998e-06*WS1' L=1.8e-7
MP_FA12_X0_10A p12 FA12_X0_ab FA12_X0_p10 vdd PM W='3.5999999999999998e-06*WS1' L=1.8e-7
MP_FA12_X0_10B FA12_X0_p10 b12 vdd vdd PM W='3.5999999999999998e-06*WS1' L=1.8e-7
MN_FA12_X1_IA FA12_X1_ab p12 0 0 NM W='1.1999999999999999e-06*WS0' L=1.8e-7
MP_FA12_X1_IA FA12_X1_ab p12 vdd vdd PM W='2.3999999999999999e-06*WS0' L=1.8e-7
MN_FA12_X1_IB FA12_X1_bb c12 0 0 NM W='1.1999999999999999e-06*WS0' L=1.8e-7
MP_FA12_X1_IB FA12_X1_bb c12 vdd vdd PM W='2.3999999999999999e-06*WS0' L=1.8e-7
MN_FA12_X1_00A sum12 FA12_X1_ab FA12_X1_n00 0 NM W='1.7999999999999999e-06*WS1' L=1.8e-7
MN_FA12_X1_00B FA12_X1_n00 FA12_X1_bb 0 0 NM W='1.7999999999999999e-06*WS1' L=1.8e-7
MN_FA12_X1_11A sum12 p12 FA12_X1_n11 0 NM W='1.7999999999999999e-06*WS1' L=1.8e-7
MN_FA12_X1_11B FA12_X1_n11 c12 0 0 NM W='1.7999999999999999e-06*WS1' L=1.8e-7
MP_FA12_X1_01A sum12 p12 FA12_X1_p01 vdd PM W='3.5999999999999998e-06*WS1' L=1.8e-7
MP_FA12_X1_01B FA12_X1_p01 FA12_X1_bb vdd vdd PM W='3.5999999999999998e-06*WS1' L=1.8e-7
MP_FA12_X1_10A sum12 FA12_X1_ab FA12_X1_p10 vdd PM W='3.5999999999999998e-06*WS1' L=1.8e-7
MP_FA12_X1_10B FA12_X1_p10 c12 vdd vdd PM W='3.5999999999999998e-06*WS1' L=1.8e-7
MN_FA12_NAB_A nab12 a12 FA12_NAB_mid 0 NM W='2.3999999999999999e-06*WS2' L=1.8e-7
MN_FA12_NAB_B FA12_NAB_mid b12 0 0 NM W='2.3999999999999999e-06*WS2' L=1.8e-7
MP_FA12_NAB_A nab12 a12 vdd vdd PM W='4.7999999999999998e-06*WS2' L=1.8e-7
MP_FA12_NAB_B nab12 b12 vdd vdd PM W='4.7999999999999998e-06*WS2' L=1.8e-7
MN_FA12_NPC_A npc12 p12 FA12_NPC_mid 0 NM W='2.3999999999999999e-06*WS2' L=1.8e-7
MN_FA12_NPC_B FA12_NPC_mid c12 0 0 NM W='2.3999999999999999e-06*WS2' L=1.8e-7
MP_FA12_NPC_A npc12 p12 vdd vdd PM W='4.7999999999999998e-06*WS2' L=1.8e-7
MP_FA12_NPC_B npc12 c12 vdd vdd PM W='4.7999999999999998e-06*WS2' L=1.8e-7
MN_FA12_COUT_A c13 nab12 FA12_COUT_mid 0 NM W='7.9999999999999996e-06*WS3' L=1.8e-7
MN_FA12_COUT_B FA12_COUT_mid npc12 0 0 NM W='7.9999999999999996e-06*WS3' L=1.8e-7
MP_FA12_COUT_A c13 nab12 vdd vdd PM W='1.5999999999999999e-05*WS3' L=1.8e-7
MP_FA12_COUT_B c13 npc12 vdd vdd PM W='1.5999999999999999e-05*WS3' L=1.8e-7
MN_FA13_X0_IA FA13_X0_ab a13 0 0 NM W='1.1999999999999999e-06*WS0' L=1.8e-7
MP_FA13_X0_IA FA13_X0_ab a13 vdd vdd PM W='2.3999999999999999e-06*WS0' L=1.8e-7
MN_FA13_X0_IB FA13_X0_bb b13 0 0 NM W='1.1999999999999999e-06*WS0' L=1.8e-7
MP_FA13_X0_IB FA13_X0_bb b13 vdd vdd PM W='2.3999999999999999e-06*WS0' L=1.8e-7
MN_FA13_X0_00A p13 FA13_X0_ab FA13_X0_n00 0 NM W='1.7999999999999999e-06*WS1' L=1.8e-7
MN_FA13_X0_00B FA13_X0_n00 FA13_X0_bb 0 0 NM W='1.7999999999999999e-06*WS1' L=1.8e-7
MN_FA13_X0_11A p13 a13 FA13_X0_n11 0 NM W='1.7999999999999999e-06*WS1' L=1.8e-7
MN_FA13_X0_11B FA13_X0_n11 b13 0 0 NM W='1.7999999999999999e-06*WS1' L=1.8e-7
MP_FA13_X0_01A p13 a13 FA13_X0_p01 vdd PM W='3.5999999999999998e-06*WS1' L=1.8e-7
MP_FA13_X0_01B FA13_X0_p01 FA13_X0_bb vdd vdd PM W='3.5999999999999998e-06*WS1' L=1.8e-7
MP_FA13_X0_10A p13 FA13_X0_ab FA13_X0_p10 vdd PM W='3.5999999999999998e-06*WS1' L=1.8e-7
MP_FA13_X0_10B FA13_X0_p10 b13 vdd vdd PM W='3.5999999999999998e-06*WS1' L=1.8e-7
MN_FA13_X1_IA FA13_X1_ab p13 0 0 NM W='1.1999999999999999e-06*WS0' L=1.8e-7
MP_FA13_X1_IA FA13_X1_ab p13 vdd vdd PM W='2.3999999999999999e-06*WS0' L=1.8e-7
MN_FA13_X1_IB FA13_X1_bb c13 0 0 NM W='1.1999999999999999e-06*WS0' L=1.8e-7
MP_FA13_X1_IB FA13_X1_bb c13 vdd vdd PM W='2.3999999999999999e-06*WS0' L=1.8e-7
MN_FA13_X1_00A sum13 FA13_X1_ab FA13_X1_n00 0 NM W='1.7999999999999999e-06*WS1' L=1.8e-7
MN_FA13_X1_00B FA13_X1_n00 FA13_X1_bb 0 0 NM W='1.7999999999999999e-06*WS1' L=1.8e-7
MN_FA13_X1_11A sum13 p13 FA13_X1_n11 0 NM W='1.7999999999999999e-06*WS1' L=1.8e-7
MN_FA13_X1_11B FA13_X1_n11 c13 0 0 NM W='1.7999999999999999e-06*WS1' L=1.8e-7
MP_FA13_X1_01A sum13 p13 FA13_X1_p01 vdd PM W='3.5999999999999998e-06*WS1' L=1.8e-7
MP_FA13_X1_01B FA13_X1_p01 FA13_X1_bb vdd vdd PM W='3.5999999999999998e-06*WS1' L=1.8e-7
MP_FA13_X1_10A sum13 FA13_X1_ab FA13_X1_p10 vdd PM W='3.5999999999999998e-06*WS1' L=1.8e-7
MP_FA13_X1_10B FA13_X1_p10 c13 vdd vdd PM W='3.5999999999999998e-06*WS1' L=1.8e-7
MN_FA13_NAB_A nab13 a13 FA13_NAB_mid 0 NM W='2.3999999999999999e-06*WS2' L=1.8e-7
MN_FA13_NAB_B FA13_NAB_mid b13 0 0 NM W='2.3999999999999999e-06*WS2' L=1.8e-7
MP_FA13_NAB_A nab13 a13 vdd vdd PM W='4.7999999999999998e-06*WS2' L=1.8e-7
MP_FA13_NAB_B nab13 b13 vdd vdd PM W='4.7999999999999998e-06*WS2' L=1.8e-7
MN_FA13_NPC_A npc13 p13 FA13_NPC_mid 0 NM W='2.3999999999999999e-06*WS2' L=1.8e-7
MN_FA13_NPC_B FA13_NPC_mid c13 0 0 NM W='2.3999999999999999e-06*WS2' L=1.8e-7
MP_FA13_NPC_A npc13 p13 vdd vdd PM W='4.7999999999999998e-06*WS2' L=1.8e-7
MP_FA13_NPC_B npc13 c13 vdd vdd PM W='4.7999999999999998e-06*WS2' L=1.8e-7
MN_FA13_COUT_A c14 nab13 FA13_COUT_mid 0 NM W='7.9999999999999996e-06*WS3' L=1.8e-7
MN_FA13_COUT_B FA13_COUT_mid npc13 0 0 NM W='7.9999999999999996e-06*WS3' L=1.8e-7
MP_FA13_COUT_A c14 nab13 vdd vdd PM W='1.5999999999999999e-05*WS3' L=1.8e-7
MP_FA13_COUT_B c14 npc13 vdd vdd PM W='1.5999999999999999e-05*WS3' L=1.8e-7
MN_FA14_X0_IA FA14_X0_ab a14 0 0 NM W='1.1999999999999999e-06*WS0' L=1.8e-7
MP_FA14_X0_IA FA14_X0_ab a14 vdd vdd PM W='2.3999999999999999e-06*WS0' L=1.8e-7
MN_FA14_X0_IB FA14_X0_bb b14 0 0 NM W='1.1999999999999999e-06*WS0' L=1.8e-7
MP_FA14_X0_IB FA14_X0_bb b14 vdd vdd PM W='2.3999999999999999e-06*WS0' L=1.8e-7
MN_FA14_X0_00A p14 FA14_X0_ab FA14_X0_n00 0 NM W='1.7999999999999999e-06*WS1' L=1.8e-7
MN_FA14_X0_00B FA14_X0_n00 FA14_X0_bb 0 0 NM W='1.7999999999999999e-06*WS1' L=1.8e-7
MN_FA14_X0_11A p14 a14 FA14_X0_n11 0 NM W='1.7999999999999999e-06*WS1' L=1.8e-7
MN_FA14_X0_11B FA14_X0_n11 b14 0 0 NM W='1.7999999999999999e-06*WS1' L=1.8e-7
MP_FA14_X0_01A p14 a14 FA14_X0_p01 vdd PM W='3.5999999999999998e-06*WS1' L=1.8e-7
MP_FA14_X0_01B FA14_X0_p01 FA14_X0_bb vdd vdd PM W='3.5999999999999998e-06*WS1' L=1.8e-7
MP_FA14_X0_10A p14 FA14_X0_ab FA14_X0_p10 vdd PM W='3.5999999999999998e-06*WS1' L=1.8e-7
MP_FA14_X0_10B FA14_X0_p10 b14 vdd vdd PM W='3.5999999999999998e-06*WS1' L=1.8e-7
MN_FA14_X1_IA FA14_X1_ab p14 0 0 NM W='1.1999999999999999e-06*WS0' L=1.8e-7
MP_FA14_X1_IA FA14_X1_ab p14 vdd vdd PM W='2.3999999999999999e-06*WS0' L=1.8e-7
MN_FA14_X1_IB FA14_X1_bb c14 0 0 NM W='1.1999999999999999e-06*WS0' L=1.8e-7
MP_FA14_X1_IB FA14_X1_bb c14 vdd vdd PM W='2.3999999999999999e-06*WS0' L=1.8e-7
MN_FA14_X1_00A sum14 FA14_X1_ab FA14_X1_n00 0 NM W='1.7999999999999999e-06*WS1' L=1.8e-7
MN_FA14_X1_00B FA14_X1_n00 FA14_X1_bb 0 0 NM W='1.7999999999999999e-06*WS1' L=1.8e-7
MN_FA14_X1_11A sum14 p14 FA14_X1_n11 0 NM W='1.7999999999999999e-06*WS1' L=1.8e-7
MN_FA14_X1_11B FA14_X1_n11 c14 0 0 NM W='1.7999999999999999e-06*WS1' L=1.8e-7
MP_FA14_X1_01A sum14 p14 FA14_X1_p01 vdd PM W='3.5999999999999998e-06*WS1' L=1.8e-7
MP_FA14_X1_01B FA14_X1_p01 FA14_X1_bb vdd vdd PM W='3.5999999999999998e-06*WS1' L=1.8e-7
MP_FA14_X1_10A sum14 FA14_X1_ab FA14_X1_p10 vdd PM W='3.5999999999999998e-06*WS1' L=1.8e-7
MP_FA14_X1_10B FA14_X1_p10 c14 vdd vdd PM W='3.5999999999999998e-06*WS1' L=1.8e-7
MN_FA14_NAB_A nab14 a14 FA14_NAB_mid 0 NM W='2.3999999999999999e-06*WS2' L=1.8e-7
MN_FA14_NAB_B FA14_NAB_mid b14 0 0 NM W='2.3999999999999999e-06*WS2' L=1.8e-7
MP_FA14_NAB_A nab14 a14 vdd vdd PM W='4.7999999999999998e-06*WS2' L=1.8e-7
MP_FA14_NAB_B nab14 b14 vdd vdd PM W='4.7999999999999998e-06*WS2' L=1.8e-7
MN_FA14_NPC_A npc14 p14 FA14_NPC_mid 0 NM W='2.3999999999999999e-06*WS2' L=1.8e-7
MN_FA14_NPC_B FA14_NPC_mid c14 0 0 NM W='2.3999999999999999e-06*WS2' L=1.8e-7
MP_FA14_NPC_A npc14 p14 vdd vdd PM W='4.7999999999999998e-06*WS2' L=1.8e-7
MP_FA14_NPC_B npc14 c14 vdd vdd PM W='4.7999999999999998e-06*WS2' L=1.8e-7
MN_FA14_COUT_A c15 nab14 FA14_COUT_mid 0 NM W='7.9999999999999996e-06*WS3' L=1.8e-7
MN_FA14_COUT_B FA14_COUT_mid npc14 0 0 NM W='7.9999999999999996e-06*WS3' L=1.8e-7
MP_FA14_COUT_A c15 nab14 vdd vdd PM W='1.5999999999999999e-05*WS3' L=1.8e-7
MP_FA14_COUT_B c15 npc14 vdd vdd PM W='1.5999999999999999e-05*WS3' L=1.8e-7
MN_FA15_X0_IA FA15_X0_ab a15 0 0 NM W='1.1999999999999999e-06*WS0' L=1.8e-7
MP_FA15_X0_IA FA15_X0_ab a15 vdd vdd PM W='2.3999999999999999e-06*WS0' L=1.8e-7
MN_FA15_X0_IB FA15_X0_bb b15 0 0 NM W='1.1999999999999999e-06*WS0' L=1.8e-7
MP_FA15_X0_IB FA15_X0_bb b15 vdd vdd PM W='2.3999999999999999e-06*WS0' L=1.8e-7
MN_FA15_X0_00A p15 FA15_X0_ab FA15_X0_n00 0 NM W='1.7999999999999999e-06*WS1' L=1.8e-7
MN_FA15_X0_00B FA15_X0_n00 FA15_X0_bb 0 0 NM W='1.7999999999999999e-06*WS1' L=1.8e-7
MN_FA15_X0_11A p15 a15 FA15_X0_n11 0 NM W='1.7999999999999999e-06*WS1' L=1.8e-7
MN_FA15_X0_11B FA15_X0_n11 b15 0 0 NM W='1.7999999999999999e-06*WS1' L=1.8e-7
MP_FA15_X0_01A p15 a15 FA15_X0_p01 vdd PM W='3.5999999999999998e-06*WS1' L=1.8e-7
MP_FA15_X0_01B FA15_X0_p01 FA15_X0_bb vdd vdd PM W='3.5999999999999998e-06*WS1' L=1.8e-7
MP_FA15_X0_10A p15 FA15_X0_ab FA15_X0_p10 vdd PM W='3.5999999999999998e-06*WS1' L=1.8e-7
MP_FA15_X0_10B FA15_X0_p10 b15 vdd vdd PM W='3.5999999999999998e-06*WS1' L=1.8e-7
MN_FA15_X1_IA FA15_X1_ab p15 0 0 NM W='1.1999999999999999e-06*WS0' L=1.8e-7
MP_FA15_X1_IA FA15_X1_ab p15 vdd vdd PM W='2.3999999999999999e-06*WS0' L=1.8e-7
MN_FA15_X1_IB FA15_X1_bb c15 0 0 NM W='1.1999999999999999e-06*WS0' L=1.8e-7
MP_FA15_X1_IB FA15_X1_bb c15 vdd vdd PM W='2.3999999999999999e-06*WS0' L=1.8e-7
MN_FA15_X1_00A sum15 FA15_X1_ab FA15_X1_n00 0 NM W='1.7999999999999999e-06*WS1' L=1.8e-7
MN_FA15_X1_00B FA15_X1_n00 FA15_X1_bb 0 0 NM W='1.7999999999999999e-06*WS1' L=1.8e-7
MN_FA15_X1_11A sum15 p15 FA15_X1_n11 0 NM W='1.7999999999999999e-06*WS1' L=1.8e-7
MN_FA15_X1_11B FA15_X1_n11 c15 0 0 NM W='1.7999999999999999e-06*WS1' L=1.8e-7
MP_FA15_X1_01A sum15 p15 FA15_X1_p01 vdd PM W='3.5999999999999998e-06*WS1' L=1.8e-7
MP_FA15_X1_01B FA15_X1_p01 FA15_X1_bb vdd vdd PM W='3.5999999999999998e-06*WS1' L=1.8e-7
MP_FA15_X1_10A sum15 FA15_X1_ab FA15_X1_p10 vdd PM W='3.5999999999999998e-06*WS1' L=1.8e-7
MP_FA15_X1_10B FA15_X1_p10 c15 vdd vdd PM W='3.5999999999999998e-06*WS1' L=1.8e-7
MN_FA15_NAB_A nab15 a15 FA15_NAB_mid 0 NM W='2.3999999999999999e-06*WS2' L=1.8e-7
MN_FA15_NAB_B FA15_NAB_mid b15 0 0 NM W='2.3999999999999999e-06*WS2' L=1.8e-7
MP_FA15_NAB_A nab15 a15 vdd vdd PM W='4.7999999999999998e-06*WS2' L=1.8e-7
MP_FA15_NAB_B nab15 b15 vdd vdd PM W='4.7999999999999998e-06*WS2' L=1.8e-7
MN_FA15_NPC_A npc15 p15 FA15_NPC_mid 0 NM W='2.3999999999999999e-06*WS2' L=1.8e-7
MN_FA15_NPC_B FA15_NPC_mid c15 0 0 NM W='2.3999999999999999e-06*WS2' L=1.8e-7
MP_FA15_NPC_A npc15 p15 vdd vdd PM W='4.7999999999999998e-06*WS2' L=1.8e-7
MP_FA15_NPC_B npc15 c15 vdd vdd PM W='4.7999999999999998e-06*WS2' L=1.8e-7
MN_FA15_COUT_A c16 nab15 FA15_COUT_mid 0 NM W='7.9999999999999996e-06*WS3' L=1.8e-7
MN_FA15_COUT_B FA15_COUT_mid npc15 0 0 NM W='7.9999999999999996e-06*WS3' L=1.8e-7
MP_FA15_COUT_A c16 nab15 vdd vdd PM W='1.5999999999999999e-05*WS3' L=1.8e-7
MP_FA15_COUT_B c16 npc15 vdd vdd PM W='1.5999999999999999e-05*WS3' L=1.8e-7
MN_COUT_BUF0 cout_b c16 0 0 NM W='7.9999999999999996e-06*WS3' L=1.8e-7
MP_COUT_BUF0 cout_b c16 vdd vdd PM W='1.5999999999999999e-05*WS3' L=1.8e-7
MN_COUT_BUF1 cout cout_b 0 0 NM W='7.9999999999999996e-06*WS3' L=1.8e-7
MP_COUT_BUF1 cout cout_b vdd vdd PM W='1.5999999999999999e-05*WS3' L=1.8e-7
CLOAD_sum00 sum00 0 2e-14
CLOAD_sum05 sum05 0 2e-14
CLOAD_sum10 sum10 0 2e-14
CLOAD_sum15 sum15 0 2e-14
CLOAD_c04 c04 0 2e-14
CLOAD_c08 c08 0 2e-14
CLOAD_c12 c12 0 2e-14
CLOAD_cout cout 0 2e-14
.tran 0.5n 40.0n 0 0.5n
.alter p000001
.param VTHN=0.4416960313164332 VTHP=-0.4532675514368949 U0N=0.054724914205196845 U0P=0.020404897023237323 RDSWN=97.576109085495176 RDSWP=116.85102835365008 VSATN=75478.12811154114 VSATP=77062.760408557355 ETA0N=0.080435244689600047 ETA0P=0.076607981130987865 WS0=1.0178994352543229 WS1=0.98263236961936784 WS2=1.0415687192824925 WS3=1.0547795127571304
.alter p000002
.param VTHN=0.46491769949940609 VTHP=-0.45865466766240509 U0N=0.046727852190048734 U0P=0.018425943840254033 RDSWN=104.78000927547589 RDSWP=113.35504216102532 VSATN=78677.730953723207 VSATP=74876.706575867516 ETA0N=0.080084308024550105 ETA0P=0.077970201016476295 WS0=1.088283844172778 WS1=0.9342640679167451 WS2=1.0713255540580897 WS3=0.99484078422620237
.alter p000003
.param VTHN=0.45667128430832954 VTHP=-0.47250069269426731 U0N=0.047759465422216825 U0P=0.01891063529661248 RDSWN=108.53063414393735 RDSWP=108.96779365498017 VSATN=86118.979285999318 VSATP=76162.810464638082 ETA0N=0.075014434473199387 ETA0P=0.078502203644315385 WS0=1.0371247722231445 WS1=1.0550425731897928 WS2=0.92532304738848803 WS3=1.0866314150251111
.alter p000004
.param VTHN=0.42887517271908149 VTHP=-0.44641858129778245 U0N=0.052076722159991443 U0P=0.018133164379206663 RDSWN=97.825918937038011 RDSWP=114.04744445207079 VSATN=81628.125581516491 VSATP=75439.647769938412 ETA0N=0.073789423157502532 ETA0P=0.087891071905445164 WS0=0.90157231341960808 WS1=0.90084149641583744 WS2=1.0885479940738818 WS3=1.0643917650893009
.alter p000005
.param VTHN=0.42062976228570609 VTHP=-0.47532511469164346 U0N=0.045986391342465655 U0P=0.0207865039080629 RDSWN=91.57719414651001 RDSWP=124.15476689493943 VSATN=73421.275473975227 VSATP=86011.616771304543 ETA0N=0.082291906621727029 ETA0P=0.075283092756474268 WS0=1.0738836304791741 WS1=1.0747705751756211 WS2=0.92023215427767324 WS3=1.0906466519882607
.alter p000006
.param VTHN=0.42138780776688017 VTHP=-0.42322228605583578 U0N=0.047359720325786003 U0P=0.02076627523936582 RDSWN=94.635862262155541 RDSWP=112.08739725960683 VSATN=85948.727223747919 VSATP=86077.072288854921 ETA0N=0.085976119657146022 ETA0P=0.086354164174372069 WS0=0.93949918453018033 WS1=1.0184266608053729 WS2=1.0827542532567387 WS3=0.92158507920998622
.alter p000007
.param VTHN=0.46812422049213187 VTHP=-0.43730854524382734 U0N=0.053452486719753722 U0P=0.01818899910651512 RDSWN=107.54347614911727 RDSWP=122.48052288265656 VSATN=75740.432771009859 VSATP=87484.796977788574 ETA0N=0.074216356099342698 ETA0P=0.081576772900871897 WS0=0.93697611759489019 WS1=0.99170689585539273 WS2=1.0460596227919086 WS3=1.0478662646431864
.alter p000008
.param VTHN=0.4736271953963182 VTHP=-0.42787136856370245 U0N=0.049086589780280382 U0P=0.01880149311864698 RDSWN=100.57080509450454 RDSWP=128.01324363712268 VSATN=87896.275986940629 VSATP=86794.766491619899 ETA0N=0.08277948353215947 ETA0P=0.074727202431229933 WS0=1.0558060639899538 WS1=0.93721643908579577 WS2=1.0958492461173266 WS3=0.93104808354788071
.alter p000009
.param VTHN=0.46113088651321543 VTHP=-0.45951877739644703 U0N=0.045507117306345879 U0P=0.020092225027548007 RDSWN=94.306886023369273 RDSWP=120.88687407697961 VSATN=76243.390353242459 VSATP=75871.08660228677 ETA0N=0.077750377671547605 ETA0P=0.081609608179626911 WS0=0.95857051896890766 WS1=0.90002993035741052 WS2=0.92645191792125892 WS3=1.0399229736609898
.alter p000010
.param VTHN=0.45404444337550692 VTHP=-0.44526248748522901 U0N=0.047378691626468468 U0P=0.018332848775408413 RDSWN=105.74139629776036 RDSWP=121.14472570783518 VSATN=79112.571770226961 VSATP=83688.404214029433 ETA0N=0.075485982983022268 ETA0P=0.077061072350568374 WS0=1.066898081309466 WS1=1.0980220808569094 WS2=1.0324536632477501 WS3=0.9884622483738883
.alter p000011
.param VTHN=0.47323242409370297 VTHP=-0.43391134824729866 U0N=0.053011773794342021 U0P=0.019130334161729566 RDSWN=105.83447483771815 RDSWP=116.28629336043042 VSATN=87760.933355770903 VSATP=72638.982889843814 ETA0N=0.081096953358928414 ETA0P=0.079421337906943515 WS0=0.98024539086601803 WS1=0.9505882583911015 WS2=0.92869247836939661 WS3=1.0253284893467645
.alter p000012
.param VTHN=0.4457378098221248 VTHP=-0.43591502358579559 U0N=0.046081427408600217 U0P=0.019018886208324128 RDSWN=100.75969591064674 RDSWP=128.96916030165517 VSATN=82272.583008271075 VSATP=84638.780188128192 ETA0N=0.085799870204509257 ETA0P=0.073691760059541089 WS0=1.0060757674169805 WS1=0.99009381928389717 WS2=0.96957565372771537 WS3=0.94463840119088727
.alter p000013
.param VTHN=0.45036997572507498 VTHP=-0.4340934330331116 U0N=0.053082025219420834 U0P=0.019657839028668422 RDSWN=102.06972799660751 RDSWP=109.35921718691797 VSATN=72763.615192496713 VSATP=85827.969343109493 ETA0N=0.085059623457668293 ETA0P=0.074821141390591234 WS0=0.9824837531255064 WS1=0.96624779296170427 WS2=1.0981016814617566 WS3=0.98283645456232938
.alter p000014
.param VTHN=0.42589150210194737 VTHP=-0.42981690055205241 U0N=0.048164641217214137 U0P=0.019412399622300285 RDSWN=99.436018622185287 RDSWP=123.64500754437195 VSATN=73588.834523961501 VSATP=74235.51483267505 ETA0N=0.086360138397820571 ETA0P=0.086477637980987454 WS0=1.0582909393322271 WS1=1.0796556259643169 WS2=0.97456747233434349 WS3=1.0291435933117381
.alter p000015
.param VTHN=0.42792153684236295 VTHP=-0.47714511023425005 U0N=0.05421779283834248 U0P=0.020563508130432343 RDSWN=98.043428282352693 RDSWP=113.19830233631106 VSATN=80985.015256673767 VSATP=79777.186760795579 ETA0N=0.078487142864782769 ETA0P=0.076857098800277052 WS0=0.96399362279344558 WS1=0.98157719369537166 WS2=1.0154306890387488 WS3=1.0216187323107231
.alter p000016
.param VTHN=0.47674935245046757 VTHP=-0.44581627164719484 U0N=0.046233018664728794 U0P=0.020195342769425861 RDSWN=109.31106631417734 RDSWP=109.00832995046163 VSATN=87776.501810399874 VSATP=86663.120256277107 ETA0N=0.079188562609036561 ETA0P=0.075250016709981771 WS0=1.0948795373682341 WS1=0.99300590520476761 WS2=1.055170189845112 WS3=0.92163185957686344
.alter p000017
.param VTHN=0.44287269005987751 VTHP=-0.4352500826314506 U0N=0.047225057657365913 U0P=0.019912416127296551 RDSWN=100.63185444199689 RDSWP=127.30887342008364 VSATN=83511.479932428163 VSATP=84911.693166896846 ETA0N=0.073439848765491811 ETA0P=0.086202000222877037 WS0=1.080573450728747 WS1=1.0541935177168966 WS2=1.086358713999735 WS3=0.92504829077261341
.alter p000018
.param VTHN=0.46604716207932573 VTHP=-0.47550367160792506 U0N=0.045185374062198601 U0P=0.021108287998445632 RDSWN=96.205353602716386 RDSWP=125.61571421186781 VSATN=87952.394238217239 VSATP=84254.51210770497 ETA0N=0.084544398602124038 ETA0P=0.085858793349139567 WS0=1.0964529786623103 WS1=1.032720695443232 WS2=1.0612142051958302 WS3=0.90314198747664542
.alter p000019
.param VTHN=0.47137355387929986 VTHP=-0.45640444557404863 U0N=0.045116013756376139 U0P=0.018075756325022993 RDSWN=90.183670874467026 RDSWP=129.68397319477307 VSATN=85893.354737531408 VSATP=72815.64950966055 ETA0N=0.087294283187993704 ETA0P=0.080982601471054752 WS0=1.0747660793456244 WS1=0.91878363108923977 WS2=1.0123204116125364 WS3=0.94050457079420668
.alter p000020
.param VTHN=0.43311604125471032 VTHP=-0.47315509651398119 U0N=0.054061359524004218 U0P=0.020083384712130663 RDSWN=106.08302853246711 RDSWP=114.21853675167812 VSATN=75219.776303912004 VSATP=76653.837331110335 ETA0N=0.072322389970367246 ETA0P=0.076230974102417068 WS0=1.0514721438728025 WS1=0.92719657647082343 WS2=1.085869201012754 WS3=0.96401929352660687
.alter p000021
.param VTHN=0.44021866282092953 VTHP=-0.47482897166145061 U0N=0.048292798380353018 U0P=0.020395006090049284 RDSWN=99.828885694364118 RDSWP=125.5678243174227 VSATN=81903.00999981942 VSATP=76278.891424847738 ETA0N=0.085710326198217293 ETA0P=0.073820357667436165 WS0=0.97002283308540305 WS1=0.9731366507195931 WS2=0.97214393910002261 WS3=0.9349773137206645
.alter p000022
.param VTHN=0.42152232425274616 VTHP=-0.47530837791992298 U0N=0.046448617222289774 U0P=0.020965040861766353 RDSWN=90.138097737193505 RDSWP=116.88919706658662 VSATN=74781.488135226886 VSATP=81041.320639165322 ETA0N=0.078379454496909862 ETA0P=0.078832430967311268 WS0=1.0590704049775483 WS1=1.0229222201027284 WS2=0.96308057283001058 WS3=1.0582823737011522
.alter p000023
.param VTHN=0.43615073866887327 VTHP=-0.42484588756280217 U0N=0.046807746755207637 U0P=0.018411680687166296 RDSWN=101.75102834374303 RDSWP=119.40069411214294 VSATN=84953.304986411138 VSATP=86271.005467163879 ETA0N=0.077721012603189643 ETA0P=0.075313543565217189 WS0=0.91555805101699095 WS1=0.90268618613158125 WS2=0.90377693121061842 WS3=1.0853196881546683
.alter p000024
.param VTHN=0.44811353170729173 VTHP=-0.45973419983862435 U0N=0.051222934873950368 U0P=0.021735422988188133 RDSWN=95.560481923687647 RDSWP=119.78772822279343 VSATN=72294.607105678035 VSATP=80888.471157468681 ETA0N=0.086036459082838898 ETA0P=0.084359178431292814 WS0=1.0810919897082478 WS1=1.058282046453378 WS2=1.0733395678090241 WS3=1.0960030475448317
.alter p000025
.param VTHN=0.46347000109739844 VTHP=-0.47167013958761739 U0N=0.049493375689986477 U0P=0.021479623573732856 RDSWN=96.395186292875891 RDSWP=124.94534427570062 VSATN=87590.251807589666 VSATP=79884.806273938666 ETA0N=0.085930980028019674 ETA0P=0.087907460721221867 WS0=0.93221648033921811 WS1=0.94352440909611923 WS2=1.0175544411869304 WS3=0.93312056439399493
.alter p000026
.param VTHN=0.42635239407932257 VTHP=-0.47989281563450942 U0N=0.047781291029107151 U0P=0.019247115849112127 RDSWN=90.510378040265394 RDSWP=115.1871628388667 VSATN=81279.557420326935 VSATP=72657.435695942782 ETA0N=0.087951333408454041 ETA0P=0.072297498279842762 WS0=1.0324966749193374 WS1=1.0674986238501356 WS2=0.97734788735536315 WS3=1.0374011557634957
.alter p000027
.param VTHN=0.44995152318846893 VTHP=-0.44670856146444371 U0N=0.051931172188713549 U0P=0.018416867717233245 RDSWN=104.2274247060127 RDSWP=129.89528921418753 VSATN=82548.108706397063 VSATP=83306.696522737941 ETA0N=0.083228667010698199 ETA0P=0.072023166687584836 WS0=0.91332643307738171 WS1=0.98913681852598612 WS2=1.0740678271606534 WS3=1.0473282034822495
.alter p000028
.param VTHN=0.4422583098660669 VTHP=-0.44421038991070694 U0N=0.05092425119371314 U0P=0.018343863216181731 RDSWN=104.5362162156559 RDSWP=110.84639744626251 VSATN=85187.037228827336 VSATP=80350.567437264646 ETA0N=0.077911555662780047 ETA0P=0.086539115326642671 WS0=0.92353367591394087 WS1=0.984333940213584 WS2=1.0130094396220228 WS3=1.0346900055980421
.alter p000029
.param VTHN=0.44555345860267698 VTHP=-0.44261648723499125 U0N=0.050559644696496195 U0P=0.018640458501275634 RDSWN=106.58006660200634 RDSWP=112.32380062661163 VSATN=74586.583640263038 VSATP=82128.673460117992 ETA0N=0.08667743240234338 ETA0P=0.074292402385943437 WS0=0.97323922865900203 WS1=1.0651045609752303 WS2=0.93876836828057864 WS3=1.0787970813581143
.alter p000030
.param VTHN=0.42680667809947664 VTHP=-0.44913844393550084 U0N=0.051869826518594786 U0P=0.021824661941313654 RDSWN=95.30079015219134 RDSWP=111.8509309257565 VSATN=75448.482501931489 VSATP=82195.847583136128 ETA0N=0.084195711686672989 ETA0P=0.080818362735527546 WS0=1.0816562513599099 WS1=1.0707627357752338 WS2=0.93645953459520237 WS3=0.98527471638167752
.alter p000031
.param VTHN=0.44758651059088733 VTHP=-0.45746761883613146 U0N=0.052597752318542752 U0P=0.01968939023636361 RDSWN=106.42398503475491 RDSWP=128.42776420494448 VSATN=83801.56157434333 VSATP=80863.193145113459 ETA0N=0.077643450485670784 ETA0P=0.084431566803319147 WS0=0.97268405770387478 WS1=0.97339317643257695 WS2=0.99147288541703593 WS3=0.940186764712167
.alter p000032
.param VTHN=0.43048552338114809 VTHP=-0.44917414658714955 U0N=0.049398810383216155 U0P=0.019681651852989 RDSWN=95.955872948152717 RDSWP=118.93335608846371 VSATN=81514.058281224148 VSATP=79243.276362645163 ETA0N=0.076135564590116056 ETA0P=0.074103198172691898 WS0=0.93753743902729358 WS1=0.90045936127411041 WS2=0.9042648717469185 WS3=0.95430923169218529
.alter p000033
.param VTHN=0.43547092054522285 VTHP=-0.4779551408880014 U0N=0.047885154379800655 U0P=0.020685695757301226 RDSWN=109.46266832613426 RDSWP=113.81377056020602 VSATN=73870.06881566385 VSATP=82521.31016410864 ETA0N=0.073826023309681216 ETA0P=0.072995499437995409 WS0=0.95947070630656339 WS1=1.0457600937107618 WS2=1.0026007577091345 WS3=1.032502377990089
.alter p000034
.param VTHN=0.4750069118989193 VTHP=-0.45446375218854573 U0N=0.053992213048173837 U0P=0.019478088205638473 RDSWN=107.64258071721981 RDSWP=130.53796108700152 VSATN=87424.721512912089 VSATP=81161.02439038147 ETA0N=0.083699182575617301 ETA0P=0.083172811016394579 WS0=1.0901091756691998 WS1=0.9094865627199481 WS2=0.949665096879304 WS3=1.0746162940705291
.alter p000035
.param VTHN=0.42002857946247868 VTHP=-0.4794789200993731 U0N=0.047720550572638194 U0P=0.020666920916797296 RDSWN=105.70654165126143 RDSWP=122.69506171305578 VSATN=84797.435157815547 VSATP=76804.609628656501 ETA0N=0.072681913443992566 ETA0P=0.076904680161051148 WS0=0.96637383766074592 WS1=1.0936261048364564 WS2=0.97963402345185935 WS3=1.0355523577848089
.alter p000036
.param VTHN=0.44941504008520444 VTHP=-0.44624441591507163 U0N=0.053684313112904614 U0P=0.019873354421621598 RDSWN=109.09200030598491 RDSWP=114.94906565121849 VSATN=87010.765804406357 VSATP=86977.928589783056 ETA0N=0.072406256073965017 ETA0P=0.082682429648919795 WS0=0.92243668953790825 WS1=0.98662150403053395 WS2=0.95467021186856349 WS3=0.90516027205108962
.alter p000037
.param VTHN=0.4287053473595443 VTHP=-0.45623222688532261 U0N=0.050782948822173407 U0P=0.018865391318337574 RDSWN=106.26867668728664 RDSWP=119.05687682870453 VSATN=77771.426841183042 VSATP=85657.001907128317 ETA0N=0.076296600482907873 ETA0P=0.087338531638395042 WS0=0.96451998508297054 WS1=1.0418039639230114 WS2=0.93405471114098249 WS3=0.99081727783982265
.alter p000038
.param VTHN=0.42458274308321353 VTHP=-0.47806377439067577 U0N=0.051969044693871973 U0P=0.019262255708281474 RDSWN=104.18988483679888 RDSWP=113.2889853306604 VSATN=75854.525088645882 VSATP=77452.056460172389 ETA0N=0.072904227261383944 ETA0P=0.080833532221615392 WS0=1.0100307982564265 WS1=1.0794540382318014 WS2=0.97191753715423601 WS3=0.90669682718237377
.alter p000039
.param VTHN=0.45717023761875675 VTHP=-0.42944388733541572 U0N=0.050941033190008964 U0P=0.021024022536584478 RDSWN=97.84216610760528 RDSWP=109.92650186672385 VSATN=83909.961067306358 VSATP=84697.572208260506 ETA0N=0.087700623715637943 ETA0P=0.085288018444640401 WS0=1.0412226683457102 WS1=1.0393012297346951 WS2=1.0249780124903607 WS3=0.91745826771112737
.alter p000040
.param VTHN=0.46778139479323116 VTHP=-0.43598382154775595 U0N=0.053140011941643341 U0P=0.018548038888764756 RDSWN=109.37466476243233 RDSWP=118.07077845905815 VSATN=84324.624879808471 VSATP=81495.178213255218 ETA0N=0.078906689591196802 ETA0P=0.072877226973487558 WS0=1.0793979829922353 WS1=0.9399813134488183 WS2=1.0731697143228258 WS3=0.91956741754512905
.alter p000041
.param VTHN=0.47100534002471717 VTHP=-0.46200227947617656 U0N=0.045158988858499095 U0P=0.020030983874784438 RDSWN=101.81989911574331 RDSWP=129.57539528703131 VSATN=79609.333317704324 VSATP=73391.502997183954 ETA0N=0.077419018761324759 ETA0P=0.087324900990737947 WS0=1.0410708099910131 WS1=1.0245041584057519 WS2=1.0789593296323989 WS3=0.91661862032866914
.alter p000042
.param VTHN=0.42561960453719627 VTHP=-0.45064991379263297 U0N=0.050201049879777387 U0P=0.01810205584092929 RDSWN=97.600977846740051 RDSWP=110.75021786510801 VSATN=81678.734762206252 VSATP=75393.866319815672 ETA0N=0.078161520720021332 ETA0P=0.072415097204934692 WS0=1.0221607141475535 WS1=1.00001683979112 WS2=0.90728371569014388 WS3=0.9797329312456019
.alter p000043
.param VTHN=0.44532747810209117 VTHP=-0.42759172877968071 U0N=0.048031772286232226 U0P=0.021366349436951385 RDSWN=105.04569267953801 RDSWP=113.78949375346234 VSATN=76446.794228214625 VSATP=72875.858231383565 ETA0N=0.077145944838808433 ETA0P=0.077129732554176697 WS0=1.0498357623538193 WS1=0.93248513981746228 WS2=1.0892795182562733 WS3=1.0834808574238894
.alter p000044
.param VTHN=0.43058979548298804 VTHP=-0.45604953686275951 U0N=0.049513290253177578 U0P=0.019086037056737774 RDSWN=102.196818793909 RDSWP=114.30593553731023 VSATN=79430.234545168321 VSATP=81123.007784516129 ETA0N=0.074949993262998241 ETA0P=0.072850046001397412 WS0=0.92753009167949496 WS1=0.93790839516877411 WS2=1.0944061887196246 WS3=1.067865861867864
.alter p000045
.param VTHN=0.45347449468731343 VTHP=-0.44405365209971914 U0N=0.046325897469542639 U0P=0.020511657400195914 RDSWN=97.385957303320083 RDSWP=123.03546335859474 VSATN=73998.761404523 VSATP=83341.732770111965 ETA0N=0.073505186685461021 ETA0P=0.083030500875796956 WS0=1.0329253595250902 WS1=0.93682889901940902 WS2=1.0245484709204107 WS3=0.95584000995769391
.alter p000046
.param VTHN=0.4563734013712033 VTHP=-0.45836057254024848 U0N=0.049616656607798411 U0P=0.018586295227923644 RDSWN=106.38235400516439 RDSWP=108.72621259851023 VSATN=86820.963010539213 VSATP=81570.366272906453 ETA0N=0.087915790018983475 ETA0P=0.073524655099527936 WS0=0.93522403433596446 WS1=0.98573571500983825 WS2=0.94377548544454137 WS3=1.040180872670591
.alter p000047
.param VTHN=0.45560585135731285 VTHP=-0.45542288585423768 U0N=0.046405194005114253 U0P=0.020220628619400414 RDSWN=92.400738383780151 RDSWP=118.59436788796789 VSATN=84145.212761759627 VSATP=77820.421426597532 ETA0N=0.081996302339492608 ETA0P=0.078255431735585565 WS0=1.0643246055459181 WS1=0.94732895200260658 WS2=1.0752863583373411 WS3=0.95931442576254111
.alter p000048
.param VTHN=0.4517027298299045 VTHP=-0.42468934034669981 U0N=0.04613100620876056 U0P=0.01926702226937799 RDSWN=94.326812634922916 RDSWP=109.68279094963547 VSATN=78009.586160662555 VSATP=83487.857708905183 ETA0N=0.086369320485201198 ETA0P=0.075705644640004968 WS0=1.0997282464855502 WS1=0.93559586814103068 WS2=0.97811729241485978 WS3=1.077939244451217
.alter p000049
.param VTHN=0.42999917579907726 VTHP=-0.46871542292817364 U0N=0.046035428527725381 U0P=0.019543602024094827 RDSWN=93.761999762338931 RDSWP=113.86304929849372 VSATN=75985.889055620966 VSATP=82422.711456301928 ETA0N=0.083979556093815438 ETA0P=0.079057848078298243 WS0=1.0447677001657778 WS1=0.95695384795244898 WS2=0.90231261620065517 WS3=1.0928830344806484
.alter p000050
.param VTHN=0.46363813507284807 VTHP=-0.4732681575155035 U0N=0.053055771484750852 U0P=0.02146782308507094 RDSWN=93.037110311190901 RDSWP=119.24363684970596 VSATN=82996.772098513815 VSATP=73319.430498770729 ETA0N=0.076494586583277471 ETA0P=0.074597090995898424 WS0=1.0829653158641086 WS1=1.019090520420338 WS2=1.0689450563873257 WS3=0.98883061412290751
.alter p000051
.param VTHN=0.42568472605604846 VTHP=-0.47604283219673516 U0N=0.052008337307326326 U0P=0.021082834866528385 RDSWN=98.751006695936496 RDSWP=118.22446386115855 VSATN=82396.758081112872 VSATP=74825.576384593063 ETA0N=0.085503578879775943 ETA0P=0.076628546151294732 WS0=1.0516543753209358 WS1=1.0387647733078869 WS2=0.90184632378203744 WS3=1.0883083421514372
.alter p000052
.param VTHN=0.47427497348471997 VTHP=-0.43573056086105189 U0N=0.045662739415240641 U0P=0.018678861678279649 RDSWN=96.017122147510733 RDSWP=108.30753907866864 VSATN=78268.24681822554 VSATP=86885.781535006914 ETA0N=0.086326743644415532 ETA0P=0.08749646777773136 WS0=1.0836304974719386 WS1=1.0045718157807526 WS2=1.0387334672034698 WS3=1.0715197072101093
.alter p000053
.param VTHN=0.4387197610030163 VTHP=-0.45578819815331034 U0N=0.052681042849300135 U0P=0.021772477230276331 RDSWN=108.23624582480348 RDSWP=117.10186778618321 VSATN=86942.930308159368 VSATP=78559.364927800969 ETA0N=0.084996589461650784 ETA0P=0.072927899844541857 WS0=1.0865307945159748 WS1=1.026376990598862 WS2=0.9213358524868217 WS3=0.90744184792464133
.alter p000054
.param VTHN=0.42096600903295744 VTHP=-0.43536511836647501 U0N=0.052402246673039124 U0P=0.018262751503662099 RDSWN=96.961901390993461 RDSWP=108.86211837156694 VSATN=86255.632779014646 VSATP=79732.410899135342 ETA0N=0.084950423211661935 ETA0P=0.08579808180406312 WS0=0.99111059950781399 WS1=1.0758987206992301 WS2=0.94843149651447067 WS3=0.97908055562452223
.alter p000055
.param VTHN=0.46083074780405536 VTHP=-0.47560107968651016 U0N=0.05003538221183406 U0P=0.019807636689720728 RDSWN=102.8492334112821 RDSWP=117.8515380838255 VSATN=85784.482785451066 VSATP=76696.667640823202 ETA0N=0.087820948609501709 ETA0P=0.080775886047891585 WS0=1.0357697897181193 WS1=1.0571671936330866 WS2=0.98994505906484143 WS3=0.99403002624672665
.alter p000056
.param VTHN=0.42112127232281038 VTHP=-0.43566367414251117 U0N=0.049459249700067022 U0P=0.01936357701329082 RDSWN=98.144376889060268 RDSWP=127.35043396187717 VSATN=87301.505219629151 VSATP=82644.295158891095 ETA0N=0.079852767745440312 ETA0P=0.072474350365891935 WS0=0.94371505373518938 WS1=1.0682225989983025 WS2=1.0389993853120634 WS3=0.9391652832396441
.alter p000057
.param VTHN=0.44739103112232775 VTHP=-0.43186220889832194 U0N=0.045201630518539503 U0P=0.018696456667809339 RDSWN=97.678579915815419 RDSWP=129.12780292306894 VSATN=84756.486491420888 VSATP=74518.689626259569 ETA0N=0.084344907069911768 ETA0P=0.082793600383146204 WS0=1.044846807148494 WS1=0.98506424887044453 WS2=1.0699998586606645 WS3=1.0702737002728449
.alter p000058
.param VTHN=0.47765026923166781 VTHP=-0.42456960285029766 U0N=0.052626597413023238 U0P=0.018525475353737629 RDSWN=108.96186528316366 RDSWP=130.6206647354559 VSATN=76455.714354369498 VSATP=76150.370419058963 ETA0N=0.078441470982163225 ETA0P=0.083071320282263258 WS0=1.0055197450770357 WS1=0.91460360770094207 WS2=0.94557847950196083 WS3=1.0227008825750035
.alter p000059
.param VTHN=0.42782936195148757 VTHP=-0.45381399566934838 U0N=0.054553662628066171 U0P=0.021607429190328601 RDSWN=108.64168365060777 RDSWP=126.92551078881017 VSATN=80840.828863179224 VSATP=86160.598222547036 ETA0N=0.080375233720796538 ETA0P=0.079654544303971883 WS0=1.0186891447741795 WS1=0.96912751736861202 WS2=1.0471431201783497 WS3=0.9465336716459003
.alter p000060
.param VTHN=0.43573262824976366 VTHP=-0.45179921948871271 U0N=0.053600206917510454 U0P=0.020264216999158959 RDSWN=90.52341294103033 RDSWP=109.63954297405903 VSATN=76929.674942070138 VSATP=72512.928321015657 ETA0N=0.082257325940310627 ETA0P=0.081909291069649268 WS0=0.93167660236457028 WS1=0.93470374805056167 WS2=0.99685557201789088 WS3=1.0452173688047444
.alter p000061
.param VTHN=0.45209322642141458 VTHP=-0.44513937859169328 U0N=0.046998136559248067 U0P=0.021037883516887384 RDSWN=97.912412029457812 RDSWP=115.31661154535001 VSATN=73965.317969103678 VSATP=83906.162433474674 ETA0N=0.073397723594617006 ETA0P=0.075610251640821302 WS0=1.0271805168301902 WS1=1.0624473132254042 WS2=1.0523940333126918 WS3=1.0664038641415723
.alter p000062
.param VTHN=0.44409395126468215 VTHP=-0.46646069683433722 U0N=0.054962586686987031 U0P=0.020609485131663656 RDSWN=96.505450074519729 RDSWP=115.90932120173755 VSATN=73673.639670936798 VSATP=74796.700769743504 ETA0N=0.086064299923497622 ETA0P=0.082229378293768002 WS0=1.0887302884470511 WS1=0.95154624461382764 WS2=1.0581167245109602 WS3=0.98201681729807688
.alter p000063
.param VTHN=0.4761697314967443 VTHP=-0.45854432700188164 U0N=0.049358493600455487 U0P=0.020350777988055319 RDSWN=90.764692935672812 RDSWP=120.21220017963051 VSATN=79722.822856011146 VSATP=77602.706566105902 ETA0N=0.078584952830842394 ETA0P=0.075121716844235714 WS0=1.0730551381257183 WS1=1.0623891070626066 WS2=0.90291792297738083 WS3=1.0635534658666608
.alter p000064
.param VTHN=0.44961153398790688 VTHP=-0.44227410537116629 U0N=0.050266009140177662 U0P=0.01993158763894293 RDSWN=99.137876987175275 RDSWP=110.21321538118829 VSATN=79075.322638690079 VSATP=74978.15858703226 ETA0N=0.082657299669853065 ETA0P=0.087823421674454533 WS0=1.0423658939368023 WS1=1.0527322856028716 WS2=0.96522973287514457 WS3=1.0079896609007779
.alter p000065
.param VTHN=0.43395277092943801 VTHP=-0.45733786348499045 U0N=0.052911913547899696 U0P=0.020700422237308707 RDSWN=90.282875318485566 RDSWP=125.03497971562393 VSATN=77378.705806947939 VSATP=80244.754123112725 ETA0N=0.082023359186692568 ETA0P=0.072335598008562901 WS0=0.94244485833722391 WS1=0.98473652248695276 WS2=0.94594200222759373 WS3=1.0829606321253322
.alter p000066
.param VTHN=0.4641025561423654 VTHP=-0.45220961926539138 U0N=0.0544221838464332 U0P=0.018508362529940141 RDSWN=90.634895564177469 RDSWP=123.69858767834533 VSATN=76491.211361194146 VSATP=76359.268115175888 ETA0N=0.073260283648655722 ETA0P=0.076984190709043623 WS0=1.0697159170365709 WS1=1.0804950078952662 WS2=1.0587916486556379 WS3=0.9493817468492195
.alter p000067
.param VTHN=0.44489245777482983 VTHP=-0.44063199168011202 U0N=0.052155462230137381 U0P=0.018043984158917708 RDSWN=91.406917186812024 RDSWP=109.98573289664594 VSATN=83121.282773214509 VSATP=84385.155634436131 ETA0N=0.085627721267452162 ETA0P=0.07396575990532897 WS0=0.9779599497038195 WS1=1.049772823966969 WS2=1.019982460451069 WS3=0.92726990287219735
.alter p000068
.param VTHN=0.47880690760770828 VTHP=-0.46540035757883241 U0N=0.047506428865727264 U0P=0.019308150587917579 RDSWN=94.004945901241669 RDSWP=123.14965085833038 VSATN=87204.133045071387 VSATP=82794.319475345939 ETA0N=0.084760544669316443 ETA0P=0.076473476174523297 WS0=0.9900652767273026 WS1=0.95615873437870136 WS2=1.0877072542057751 WS3=0.95190831789922881
.alter p000069
.param VTHN=0.46505496112405986 VTHP=-0.43119489972865421 U0N=0.052117747525481574 U0P=0.01906756870715166 RDSWN=90.038369640353579 RDSWP=117.98795831772436 VSATN=82180.89395284465 VSATP=73726.316373589798 ETA0N=0.085858098254644369 ETA0P=0.07480563416455957 WS0=1.0773851025230441 WS1=1.0977484368818362 WS2=1.043273221734355 WS3=1.0223221847570889
.alter p000070
.param VTHN=0.44616488096316115 VTHP=-0.42774260396053537 U0N=0.045041714506013561 U0P=0.018968247014595211 RDSWN=92.82408896037461 RDSWP=115.11584622512586 VSATN=77116.78100720112 VSATP=81721.445801054622 ETA0N=0.086599821557929252 ETA0P=0.084141094523069795 WS0=0.94126597568292625 WS1=1.0768453942711715 WS2=1.0910943332111376 WS3=1.0821734510491525
.alter p000071
.param VTHN=0.44391902727497007 VTHP=-0.4619494696429422 U0N=0.050373445028829469 U0P=0.01838789851602577 RDSWN=107.39585829516369 RDSWP=118.51557799705493 VSATN=74236.19735520528 VSATP=83237.615100818468 ETA0N=0.080104132031186201 ETA0P=0.077732246011781941 WS0=1.0704349616166973 WS1=1.0382085739007616 WS2=0.94786944643142956 WS3=0.90773990513606417
.alter p000072
.param VTHN=0.45604362312797003 VTHP=-0.46424414641378803 U0N=0.051022589748719149 U0P=0.018888122711678293 RDSWN=90.930563773167606 RDSWP=123.99958722141969 VSATN=73608.224647189461 VSATP=76918.586789702225 ETA0N=0.075944770009705759 ETA0P=0.086170038055615558 WS0=0.98218972643926883 WS1=0.95540204731731737 WS2=0.95938861722367519 WS3=0.99948392726853708
.alter p000073
.param VTHN=0.46863858272020043 VTHP=-0.44244366002862096 U0N=0.053872695483888663 U0P=0.0196487863746579 RDSWN=105.5906170353698 RDSWP=130.05877542077937 VSATN=82355.301237063584 VSATP=87558.308342531833 ETA0N=0.083616601275270624 ETA0P=0.084240566517857884 WS0=0.93843758982255787 WS1=0.93669987942250921 WS2=1.0299893353687737 WS3=1.0152480009186822
.alter p000074
.param VTHN=0.47759019487477683 VTHP=-0.47137473833924332 U0N=0.047972032163013989 U0P=0.02093536939254495 RDSWN=92.32358908617249 RDSWP=118.3801218583218 VSATN=83955.063842309159 VSATP=83102.686759345816 ETA0N=0.087342486737362127 ETA0P=0.08321842645928243 WS0=0.95517528063245505 WS1=0.93030941725110239 WS2=1.0933613344725897 WS3=0.93782341853838191
.alter p000075
.param VTHN=0.45457217835575148 VTHP=-0.46157039028015573 U0N=0.048322301454096751 U0P=0.01900086614661986 RDSWN=101.05743703578439 RDSWP=127.7579441646548 VSATN=76863.334601786031 VSATP=77869.876588762592 ETA0N=0.084536921299547471 ETA0P=0.074937328493146035 WS0=1.0355046254190867 WS1=1.0667522116249128 WS2=0.97029542661209034 WS3=1.066196895187919
.alter p000076
.param VTHN=0.46042449983096362 VTHP=-0.46762009768533769 U0N=0.045751865743166711 U0P=0.018998144629446295 RDSWN=109.07826877506474 RDSWP=120.1050284406747 VSATN=86334.037946847937 VSATP=77398.760234895715 ETA0N=0.083037168072675638 ETA0P=0.087437665183457372 WS0=1.0834069570349247 WS1=1.0778998058335127 WS2=1.0974192609997555 WS3=1.0437565550964205
.alter p000077
.param VTHN=0.45391379626695566 VTHP=-0.44717955607713877 U0N=0.051092542032677629 U0P=0.021968269237159777 RDSWN=95.535129233557043 RDSWP=119.71111725041574 VSATN=74662.523795264395 VSATP=85208.762231920686 ETA0N=0.082962297934448634 ETA0P=0.087645075810632619 WS0=1.0349171812591211 WS1=0.994355883802581 WS2=1.0995769926159937 WS3=0.96855273709194345
.alter p000078
.param VTHN=0.46981929715137322 VTHP=-0.4589773338201244 U0N=0.04661057178640815 U0P=0.020387324242097563 RDSWN=92.44946721352548 RDSWP=129.88542373198854 VSATN=72014.491771212022 VSATP=84660.229813960716 ETA0N=0.080505678705331249 ETA0P=0.07543791483274602 WS0=0.9388322964419733 WS1=1.016401241329026 WS2=0.92051082433204723 WS3=1.0675681662398815
.alter p000079
.param VTHN=0.45001230529695058 VTHP=-0.47735559406834327 U0N=0.048653391566843458 U0P=0.018826000766893954 RDSWN=93.418462047630598 RDSWP=124.90729142406553 VSATN=82046.899182433641 VSATP=83286.729663133621 ETA0N=0.085457459111114936 ETA0P=0.080547191652663178 WS0=1.0672999870699982 WS1=0.91507638066840169 WS2=0.98392922183670306 WS3=0.93832745425728215
.alter p000080
.param VTHN=0.43179513437021816 VTHP=-0.42810394727677142 U0N=0.049226032754452177 U0P=0.021958698056729897 RDSWN=99.380689152921292 RDSWP=128.86295346550401 VSATN=84654.720208803847 VSATP=74761.052776426732 ETA0N=0.078206853944812804 ETA0P=0.076877622050011585 WS0=0.92022158173691593 WS1=1.0308474057613048 WS2=1.0547451579825817 WS3=1.0171749162845631
.alter p000081
.param VTHN=0.46308860847526084 VTHP=-0.45499841460245605 U0N=0.048591425031158299 U0P=0.018499839877220255 RDSWN=97.534100795121901 RDSWP=128.54116560216843 VSATN=84371.749021445168 VSATP=72157.282135476577 ETA0N=0.077058671949227192 ETA0P=0.08094144400145771 WS0=1.0064424710408002 WS1=1.01519493480995 WS2=0.9078118149936435 WS3=1.0162858694754391
.alter p000082
.param VTHN=0.44008383386959826 VTHP=-0.4257612949290403 U0N=0.050532303052410854 U0P=0.020694320980173698 RDSWN=100.05513554830392 RDSWP=113.55083817063317 VSATN=84420.556916409201 VSATP=85665.552376113439 ETA0N=0.083932025032156077 ETA0P=0.076525045096892119 WS0=0.97220837466336585 WS1=1.0829656811362729 WS2=1.0169970733050255 WS3=1.0750735091549364
.alter p000083
.param VTHN=0.44678503161298394 VTHP=-0.4403362055171271 U0N=0.054630425134012311 U0P=0.018065324846080533 RDSWN=92.066809885654564 RDSWP=121.96830580555593 VSATN=78627.098969676415 VSATP=77571.086277557508 ETA0N=0.084105601143342673 ETA0P=0.075768582951068267 WS0=1.0117501094821837 WS1=0.90738870954132478 WS2=1.0109910532307866 WS3=0.96157359852847446
.alter p000084
.param VTHN=0.42519664108699845 VTHP=-0.43285923115064034 U0N=0.054779538323085276 U0P=0.02166388297681341 RDSWN=100.12382131784211 RDSWP=118.16981395363752 VSATN=84095.937523018438 VSATP=79185.704024570179 ETA0N=0.080596681737628031 ETA0P=0.072981274615769531 WS0=1.027812168174127 WS1=0.98066544740150929 WS2=1.0360126630037141 WS3=0.94346205788785098
.alter p000085
.param VTHN=0.42282373450531968 VTHP=-0.44612781359275877 U0N=0.047399052883125029 U0P=0.021156991833585811 RDSWN=96.540440067122873 RDSWP=111.21813153510615 VSATN=72051.971084540026 VSATP=85622.491934363716 ETA0N=0.078068804360272914 ETA0P=0.084788063175286393 WS0=0.90848978740549535 WS1=1.011759236571266 WS2=1.0592995431187053 WS3=0.99171357692278383
.alter p000086
.param VTHN=0.43212135412214775 VTHP=-0.46523287113551365 U0N=0.054376461118064906 U0P=0.019901584249713004 RDSWN=94.402882932935967 RDSWP=130.1817237266697 VSATN=77054.89302580306 VSATP=87352.630261734128 ETA0N=0.078684861645009901 ETA0P=0.079515411858744722 WS0=0.95795262651483548 WS1=1.0426549329465666 WS2=1.0607108758484367 WS3=1.0705245437206834
.alter p000087
.param VTHN=0.4370501327493449 VTHP=-0.42649520150636988 U0N=0.050844398783904989 U0P=0.020019809480256289 RDSWN=104.89575946049285 RDSWP=119.16901191404726 VSATN=84168.318506385724 VSATP=86868.265652075148 ETA0N=0.076528269604693805 ETA0P=0.086326453698323563 WS0=1.0619541117848741 WS1=0.97226860112103008 WS2=0.91264181773206898 WS3=0.98240625070473264
.alter p000088
.param VTHN=0.46256029511972735 VTHP=-0.43626069042629145 U0N=0.053916848509133079 U0P=0.019341396233433568 RDSWN=102.12645903817533 RDSWP=129.00016328648027 VSATN=79910.573456169019 VSATP=86706.086123833113 ETA0N=0.072189879633051957 ETA0P=0.078024775158409124 WS0=0.97139198432553631 WS1=1.0546456490608054 WS2=1.0181126309506208 WS3=0.93028082521188227
.alter p000089
.param VTHN=0.47466835364697946 VTHP=-0.4513865348560625 U0N=0.051842922200661362 U0P=0.021925728473034055 RDSWN=101.59346773799876 RDSWP=110.26020363135976 VSATN=83550.602667573374 VSATP=78027.176438307928 ETA0N=0.083129675956672047 ETA0P=0.083506074382652409 WS0=1.0735663854564164 WS1=1.0338380950095996 WS2=1.0600893913388412 WS3=1.0129427212440112
.alter p000090
.param VTHN=0.42696290315731833 VTHP=-0.45509655688930717 U0N=0.047674627400721974 U0P=0.020171746970856413 RDSWN=99.517535384582871 RDSWP=122.39812629184232 VSATN=73719.376672752987 VSATP=77888.211599775997 ETA0N=0.083895488498128848 ETA0P=0.074782850014141575 WS0=1.0162295602646405 WS1=0.98610157355356987 WS2=1.0375501751854519 WS3=0.95609212178837166
.alter p000091
.param VTHN=0.46578317914892192 VTHP=-0.46774706506857161 U0N=0.050984866873692455 U0P=0.021281436908375397 RDSWN=94.923005978735148 RDSWP=112.00093849925879 VSATN=79338.345075555422 VSATP=81634.780976445414 ETA0N=0.082458154374572712 ETA0P=0.076381381340577856 WS0=0.90825406391593566 WS1=1.0040940487314156 WS2=0.92345727404550515 WS3=0.98089486154164651
.alter p000092
.param VTHN=0.46244366391349684 VTHP=-0.44826530004278475 U0N=0.045561191235258508 U0P=0.020905617758436475 RDSWN=90.086979620963419 RDSWP=123.45184585182801 VSATN=79900.25173899479 VSATP=84121.239670013965 ETA0N=0.080544596265470475 ETA0P=0.083347296019077005 WS0=1.0204030933288246 WS1=0.99846734117790936 WS2=0.91565258387599568 WS3=1.0730835368379861
.alter p000093
.param VTHN=0.43041259993800779 VTHP=-0.47023814890738297 U0N=0.045831402386502018 U0P=0.0218457278091264 RDSWN=107.25848600919167 RDSWP=123.407705352817 VSATN=86463.452329568434 VSATP=80619.058417350534 ETA0N=0.084612762596901814 ETA0P=0.087729379734553692 WS0=1.0259004439289221 WS1=1.0838533512363282 WS2=0.97382492354860906 WS3=1.0695267210151733
.alter p000094
.param VTHN=0.44178762656224541 VTHP=-0.47771303604693449 U0N=0.051188634817306074 U0P=0.018948043835920723 RDSWN=95.377058024095362 RDSWP=113.40713384790244 VSATN=85127.472844687654 VSATP=79922.430702662023 ETA0N=0.072304559663896928 ETA0P=0.087867311365476264 WS0=0.91821925177067154 WS1=1.0518915080634685 WS2=1.0795403586943628 WS3=1.0124716132372162
.alter p000095
.param VTHN=0.44189636612821087 VTHP=-0.47371462953382909 U0N=0.047559356742999194 U0P=0.019451059814094382 RDSWN=90.597533341178078 RDSWP=125.91331475541064 VSATN=81442.084384707807 VSATP=83795.635943182875 ETA0N=0.076731659127970961 ETA0P=0.083303876834694202 WS0=1.0442030315828528 WS1=1.0867093399299543 WS2=1.0526711634350667 WS3=0.99291313620836319
.alter p000096
.param VTHN=0.45744544754431365 VTHP=-0.46531447188710151 U0N=0.052347823026535303 U0P=0.019072817531461447 RDSWN=95.220507165358981 RDSWP=119.94227278800126 VSATN=73344.229842769782 VSATP=87540.59554561344 ETA0N=0.082786503310962656 ETA0P=0.073885379172452748 WS0=1.0175427468870069 WS1=0.97429111675494828 WS2=1.0962600787860035 WS3=0.90805780990094331
.alter p000097
.param VTHN=0.44634089982700315 VTHP=-0.46181146572371085 U0N=0.046172532040590658 U0P=0.021174965763096517 RDSWN=108.19110924264199 RDSWP=120.3016122108038 VSATN=80424.079419609741 VSATP=81846.827937235372 ETA0N=0.075735284484670498 ETA0P=0.073406856053151739 WS0=0.92298204412398555 WS1=0.95955579846371064 WS2=1.04807433079473 WS3=0.97931278203907024
.alter p000098
.param VTHN=0.45915032464393379 VTHP=-0.43888888034856527 U0N=0.04770826997285648 U0P=0.020278514456032886 RDSWN=101.18275969283999 RDSWP=131.40968877106283 VSATN=85256.901610303961 VSATP=73160.057887956049 ETA0N=0.080257899107872344 ETA0P=0.08000591159016239 WS0=1.0321119227046107 WS1=1.0604955590479483 WS2=0.950182894699661 WS3=0.92985367332163515
.alter p000099
.param VTHN=0.44658949988151919 VTHP=-0.45528501866956128 U0N=0.053638801799752278 U0P=0.019316156920155383 RDSWN=105.33564772378222 RDSWP=126.17819599411472 VSATN=79177.749646082593 VSATP=72896.155761992806 ETA0N=0.087902231920701637 ETA0P=0.073987155409042049 WS0=0.90195021054880153 WS1=1.0506398296008628 WS2=1.0259575807962253 WS3=1.0602229693190615
.alter p000100
.param VTHN=0.44845545611310117 VTHP=-0.46470887518068904 U0N=0.049582862469241637 U0P=0.018938236376359236 RDSWN=103.24961368710113 RDSWP=113.031573681624 VSATN=78837.719720976063 VSATP=76441.904563253978 ETA0N=0.082487176161571599 ETA0P=0.078348637912114522 WS0=1.0667822770768227 WS1=0.97668263551690038 WS2=0.93345773676212818 WS3=1.0490096338202279
.alter p000101
.param VTHN=0.47345612361848716 VTHP=-0.45465309923983088 U0N=0.048146092174381705 U0P=0.018241564283038685 RDSWN=108.01391136298781 RDSWP=120.3480465429336 VSATN=73247.120513889167 VSATP=82883.267253606798 ETA0N=0.080959079891342101 ETA0P=0.087696956272069804 WS0=0.91247521786375319 WS1=0.99737001434433603 WS2=1.0467165386547643 WS3=0.9268400047804296
.alter p000102
.param VTHN=0.47705251347659644 VTHP=-0.46055884151996962 U0N=0.052841160665192594 U0P=0.020842525131514689 RDSWN=102.54397808797756 RDSWP=118.96523030368515 VSATN=80176.825215858989 VSATP=87111.53752314538 ETA0N=0.083426107029756197 ETA0P=0.086781572354275124 WS0=0.90662683154483115 WS1=0.95971478659954601 WS2=1.0722390556672052 WS3=0.98037896727363094
.alter p000103
.param VTHN=0.43447956784017799 VTHP=-0.43753972883275577 U0N=0.049772568235721112 U0P=0.019446894090789438 RDSWN=94.910641824388463 RDSWP=111.43439973607344 VSATN=80726.07539218622 VSATP=76298.220843395873 ETA0N=0.083608479443823255 ETA0P=0.084347738859392118 WS0=0.99222481313728972 WS1=0.94423039087930571 WS2=1.0377017889136337 WS3=1.0442327874883315
.alter p000104
.param VTHN=0.43819566805821308 VTHP=-0.4632229682325808 U0N=0.048118689750440861 U0P=0.021654194751445151 RDSWN=93.813127781542775 RDSWP=125.22216065995606 VSATN=81220.759813735887 VSATP=79603.615821588784 ETA0N=0.084578160914086209 ETA0P=0.07961639234283599 WS0=1.0037950369568824 WS1=0.94850841357821802 WS2=0.92251069410667363 WS3=1.0239110842340284
.alter p000105
.param VTHN=0.44465927394034166 VTHP=-0.46730194204476616 U0N=0.046746879118416906 U0P=0.020954147583286065 RDSWN=93.973395213844597 RDSWP=119.51019537699638 VSATN=80758.769404819381 VSATP=76786.353996241407 ETA0N=0.087256660309214973 ETA0P=0.082455197844691935 WS0=0.95602858819756054 WS1=0.97067997055010746 WS2=1.0647890840257035 WS3=1.039083495611548
.alter p000106
.param VTHN=0.43522093247059518 VTHP=-0.45940767223119433 U0N=0.053733488234890922 U0P=0.02139627044375516 RDSWN=93.272107121122559 RDSWP=111.04471391273383 VSATN=80344.663587271643 VSATP=86227.195176226509 ETA0N=0.07738923578922241 ETA0P=0.072556479789858408 WS0=1.0233187756879323 WS1=0.97396590859000221 WS2=0.90810786512724528 WS3=1.0557220616727645
.alter p000107
.param VTHN=0.42670622396752234 VTHP=-0.47926173494138152 U0N=0.049219135941216734 U0P=0.018988485082164552 RDSWN=107.8400978237425 RDSWP=130.31021588702779 VSATN=87919.68567068594 VSATP=86961.351880464295 ETA0N=0.075129116863029394 ETA0P=0.074471846589279397 WS0=0.98844565584664512 WS1=1.0669751095737969 WS2=0.99021442551026018 WS3=0.99022368281032724
.alter p000108
.param VTHN=0.47212718352741939 VTHP=-0.4308709487920323 U0N=0.05485908889537195 U0P=0.02172604637161564 RDSWN=93.32204353731143 RDSWP=120.55393069379815 VSATN=87583.142352713359 VSATP=86635.254771381646 ETA0N=0.072152388156332889 ETA0P=0.078624128636624213 WS0=1.0797002271809462 WS1=0.95241514154370543 WS2=0.92190914385202161 WS3=0.97767110185816075
.alter p000109
.param VTHN=0.45021786151043502 VTHP=-0.46711549267676744 U0N=0.047003340973463009 U0P=0.018400048553146104 RDSWN=94.083457508763473 RDSWP=120.44774505988021 VSATN=81372.330390450486 VSATP=83363.939010140661 ETA0N=0.077373767437996732 ETA0P=0.083848877969463484 WS0=1.0224471864606364 WS1=1.0063680876421803 WS2=1.0069350857855557 WS3=0.95867324998422621
.alter p000110
.param VTHN=0.47160861700641887 VTHP=-0.47446785142051268 U0N=0.054085823798556545 U0P=0.019708050719353935 RDSWN=91.265952261190478 RDSWP=115.26439496446417 VSATN=73752.585333752009 VSATP=82967.367986117155 ETA0N=0.072563123038151933 ETA0P=0.087461573863725051 WS0=1.0954333042528031 WS1=0.97485957254799915 WS2=1.012799377855085 WS3=0.98045724933145784
.alter p000111
.param VTHN=0.472509771575157 VTHP=-0.45469281717342236 U0N=0.049469310257575005 U0P=0.021528521271557605 RDSWN=104.63435085629003 RDSWP=110.5772470295601 VSATN=84991.875536490683 VSATP=83035.988861624355 ETA0N=0.078429330296489935 ETA0P=0.077589560623818443 WS0=0.97835800436680787 WS1=0.96651080216527441 WS2=0.96192693042693689 WS3=1.089616987048057
.alter p000112
.param VTHN=0.42855383889038567 VTHP=-0.46293187831685512 U0N=0.0460650557163617 U0P=0.018274419413374373 RDSWN=106.30087274434158 RDSWP=125.89779435957247 VSATN=85020.618990974879 VSATP=74420.041585213432 ETA0N=0.084064729452513656 ETA0P=0.086047075249212748 WS0=1.0305743516277963 WS1=0.95759055937535342 WS2=0.91661893233228842 WS3=0.90211707174844213
.alter p000113
.param VTHN=0.44316674438073228 VTHP=-0.45568475042685264 U0N=0.046928153550185765 U0P=0.019221694518006413 RDSWN=96.701402202250947 RDSWP=108.46220183832077 VSATN=83217.737598401363 VSATP=79042.408003514473 ETA0N=0.087537751229084096 ETA0P=0.081701680190118406 WS0=1.050587747661355 WS1=0.9447932478016533 WS2=1.0578773105003614 WS3=0.9025765268157665
.alter p000114
.param VTHN=0.43458245003043228 VTHP=-0.47115846526759303 U0N=0.046277760176813995 U0P=0.020101312661930909 RDSWN=103.12374665764584 RDSWP=123.07782060157278 VSATN=83316.20854048153 VSATP=80576.614127846944 ETA0N=0.085205773448216365 ETA0P=0.073636514242399712 WS0=0.93593275121362107 WS1=1.0532923751295626 WS2=1.0802170423170485 WS3=0.90881157259145584
.alter p000115
.param VTHN=0.44093036772030642 VTHP=-0.43992665408038356 U0N=0.046526172179833736 U0P=0.019042243741465258 RDSWN=100.48993034315401 RDSWP=118.81296956853765 VSATN=77844.133244699668 VSATP=86037.63475663634 ETA0N=0.087136364658447776 ETA0P=0.074632338921941252 WS0=1.041682209003328 WS1=1.0204211706390092 WS2=0.93898467653523898 WS3=1.0890506895076237
.alter p000116
.param VTHN=0.47690868800957315 VTHP=-0.47599834511814626 U0N=0.04500884019225268 U0P=0.018567099679110608 RDSWN=99.607113297342551 RDSWP=111.83769092706051 VSATN=77338.226447680223 VSATP=85008.925242520781 ETA0N=0.072527267617211982 ETA0P=0.083948679282980013 WS0=1.0841255777565222 WS1=0.9265243194920163 WS2=1.0855349691039473 WS3=1.0857125375761345
.alter p000117
.param VTHN=0.42655707284005634 VTHP=-0.42156071422848196 U0N=0.052998844282327096 U0P=0.020516259164060309 RDSWN=96.661734977997469 RDSWP=122.16200308775191 VSATN=76918.250752314023 VSATP=84055.95669605468 ETA0N=0.081208348176877859 ETA0P=0.086715959135275786 WS0=1.0290577651430688 WS1=1.0121221351661469 WS2=0.97052572275949101 WS3=0.93584254170575742
.alter p000118
.param VTHN=0.4569942003478093 VTHP=-0.4778028526888653 U0N=0.045073163323231628 U0P=0.018791342124751264 RDSWN=92.604791759678164 RDSWP=124.87465003178852 VSATN=87087.667001302485 VSATP=86423.82602780599 ETA0N=0.073132018755268383 ETA0P=0.079087591185618478 WS0=1.0576290624150793 WS1=0.99115975932303801 WS2=1.0075518441155253 WS3=1.0430996602681875
.alter p000119
.param VTHN=0.47279801186821829 VTHP=-0.44302573105981502 U0N=0.051268726725025762 U0P=0.018235272588688685 RDSWN=92.969836131047771 RDSWP=121.92456759185509 VSATN=74993.180381117854 VSATP=86296.096118439018 ETA0N=0.086477127695582856 ETA0P=0.086617748130687733 WS0=1.0457474929114576 WS1=0.95785175106901987 WS2=1.0317481808548754 WS3=1.0797979910171751
.alter p000120
.param VTHN=0.42614549693500703 VTHP=-0.42884303794489614 U0N=0.05306102039701184 U0P=0.018638318069528353 RDSWN=91.498051152577034 RDSWP=117.71028045102689 VSATN=86094.67791258925 VSATP=83744.482737217244 ETA0N=0.080818886660269415 ETA0P=0.076704419009063426 WS0=0.94666495896446234 WS1=0.97798296559557263 WS2=0.96009977915889988 WS3=0.97158864822896585
.alter p000121
.param VTHN=0.44373627028949852 VTHP=-0.47357452975689379 U0N=0.048757050240632219 U0P=0.020300896129208556 RDSWN=102.9498047119373 RDSWP=129.48734223173719 VSATN=82666.096625658654 VSATP=78465.112782721888 ETA0N=0.077311391836379958 ETA0P=0.086513029702193794 WS0=0.99193299155110315 WS1=1.0512691196768964 WS2=0.99647026324299703 WS3=0.95298355557218728
.alter p000122
.param VTHN=0.45134067305044023 VTHP=-0.474019410137201 U0N=0.053194569589878782 U0P=0.020651009682781902 RDSWN=102.26199158188278 RDSWP=113.68712549764794 VSATN=84393.061341213397 VSATP=78383.520756057565 ETA0N=0.081315083017746703 ETA0P=0.073486918083379316 WS0=0.95401775395318977 WS1=0.96772898096296922 WS2=0.96756954812772766 WS3=1.0107481264329139
.alter p000123
.param VTHN=0.44200139699150137 VTHP=-0.46921853496068211 U0N=0.050687103875723366 U0P=0.021121606004961838 RDSWN=94.183409170338749 RDSWP=124.19841917188842 VSATN=79493.973105836441 VSATP=73936.19617951689 ETA0N=0.086802100273350141 ETA0P=0.084412847229703755 WS0=0.93979311672826815 WS1=0.91723830208908208 WS2=0.95135912801422229 WS3=1.0046771269619423
.alter p000124
.param VTHN=0.43693114059348098 VTHP=-0.47331771703420233 U0N=0.0466200757444045 U0P=0.021779759074508596 RDSWN=95.671694510207033 RDSWP=121.727024643847 VSATN=84223.516791985021 VSATP=80799.45359301538 ETA0N=0.076766566938173575 ETA0P=0.075471920091643552 WS0=1.0962417303496013 WS1=0.96208293452039428 WS2=1.0619785025518385 WS3=1.0339619243328124
.alter p000125
.param VTHN=0.42778725420661046 VTHP=-0.47417521309645749 U0N=0.054510211155707616 U0P=0.019416948774166384 RDSWN=103.7865974962138 RDSWP=122.02402939495828 VSATN=79629.559802411168 VSATP=78321.851782735233 ETA0N=0.079097639938769546 ETA0P=0.07295377912584157 WS0=1.063263271685968 WS1=0.91609723831957912 WS2=0.9762861376207298 WS3=0.97032445715313531
.alter p000126
.param VTHN=0.45371268451254831 VTHP=-0.42496861554317339 U0N=0.0471580069587475 U0P=0.020456366242641914 RDSWN=105.10777482857584 RDSWP=126.52021631490248 VSATN=74359.447344254135 VSATP=76895.345493827859 ETA0N=0.086549400637251458 ETA0P=0.072587471093596159 WS0=0.99947512633390412 WS1=1.0949300958419086 WS2=1.0145323332345479 WS3=1.0506961246705393
.alter p000127
.param VTHN=0.44240276525935096 VTHP=-0.4650748027398372 U0N=0.053399063012708345 U0P=0.018122392902451424 RDSWN=92.398174609042272 RDSWP=130.69224326212009 VSATN=87481.948166146714 VSATP=79528.359850412904 ETA0N=0.076956428161801593 ETA0P=0.085827804050662759 WS0=1.088854729122769 WS1=1.0887650174703389 WS2=1.0286169575054336 WS3=1.0198969659822446
.alter p000128
.param VTHN=0.42489593464797298 VTHP=-0.46955981763804955 U0N=0.052920581834403631 U0P=0.019559955097445458 RDSWN=96.0953951135171 RDSWP=121.00940521692196 VSATN=73337.770992444246 VSATP=81977.174968901396 ETA0N=0.081871394931632049 ETA0P=0.084485885902491009 WS0=1.0393157285217847 WS1=1.0170733707977551 WS2=0.95108715646078024 WS3=1.0515335119725489
.alter p000129
.param VTHN=0.47307829346559793 VTHP=-0.43683726974984105 U0N=0.048929254502939307 U0P=0.018308380025240285 RDSWN=103.48540914434022 RDSWP=110.80210246686252 VSATN=73471.39876574892 VSATP=85271.532016633908 ETA0N=0.076090762486235392 ETA0P=0.077337054651477263 WS0=0.90227104095623734 WS1=0.97144130827985264 WS2=1.0649895084312553 WS3=1.0567554379045208
.alter p000130
.param VTHN=0.45429694246077473 VTHP=-0.46105645661669115 U0N=0.053296226086674704 U0P=0.020135097243124272 RDSWN=100.38714321331221 RDSWP=124.42215751364955 VSATN=77308.708484125702 VSATP=74096.30048962454 ETA0N=0.084188783690721719 ETA0P=0.087655320739173301 WS0=1.0166302368411129 WS1=1.0715647287141827 WS2=1.0473797041031885 WS3=0.96565922501971657
.alter p000131
.param VTHN=0.46944339739965696 VTHP=-0.43487202341406722 U0N=0.051742196677583459 U0P=0.018225975086118559 RDSWN=104.97574536354502 RDSWP=122.57208802263827 VSATN=73893.918313055925 VSATP=79210.568811385223 ETA0N=0.083197984537904918 ETA0P=0.079003518099192385 WS0=0.92833415428695654 WS1=1.0196098378187242 WS2=0.96715583355237877 WS3=0.98385423043479281
.alter p000132
.param VTHN=0.4697614517552931 VTHP=-0.44204743064679969 U0N=0.048979333222022484 U0P=0.019355825596137775 RDSWN=95.499074125004626 RDSWP=122.80761654590685 VSATN=86580.211446392495 VSATP=72488.691705837598 ETA0N=0.073357134320854972 ETA0P=0.083825063853809584 WS0=1.0425327181970852 WS1=1.0493387860443892 WS2=1.0273055197872516 WS3=1.097330491778453
.alter p000133
.param VTHN=0.44823613500833703 VTHP=-0.45812035272522644 U0N=0.045708024899417672 U0P=0.018957465451318781 RDSWN=90.461267013194899 RDSWP=111.47103268877856 VSATN=78111.386803157438 VSATP=78741.217679989524 ETA0N=0.074999212379770974 ETA0P=0.076940165415732217 WS0=0.94908033643977541 WS1=0.99209793218412501 WS2=0.97533613572313138 WS3=1.0122854552393783
.alter p000134
.param VTHN=0.47678663015767181 VTHP=-0.43899588848931337 U0N=0.051721836726895495 U0P=0.020258402684936193 RDSWN=90.700586167909989 RDSWP=109.4754091393514 VSATN=75526.173944374299 VSATP=76028.006276344357 ETA0N=0.079668214368697393 ETA0P=0.07600146147429003 WS0=0.9863471421611798 WS1=1.0399391821357782 WS2=1.0370366388213619 WS3=1.0035769263418772
.alter p000135
.param VTHN=0.46397097369677148 VTHP=-0.47977376930093268 U0N=0.04668699721466589 U0P=0.019496371485130896 RDSWN=96.598471166366963 RDSWP=115.79923627362744 VSATN=74260.890979956006 VSATP=73858.948891099833 ETA0N=0.08107962831162463 ETA0P=0.085258092904081137 WS0=0.9270083685892615 WS1=0.99358606970098484 WS2=0.95067560077476887 WS3=1.0449753555194754
.alter p000136
.param VTHN=0.45237773989023172 VTHP=-0.46083995558386937 U0N=0.054595690650416411 U0P=0.019626530488456681 RDSWN=108.49164238273525 RDSWP=116.56430828091128 VSATN=86357.448189553557 VSATP=80180.280074735114 ETA0N=0.085651869225116681 ETA0P=0.08608714827995298 WS0=1.0473448036498132 WS1=1.0179076477571911 WS2=0.93637101909363984 WS3=0.9699181641348843
.alter p000137
.param VTHN=0.45513719348554726 VTHP=-0.42279062610972512 U0N=0.05242501434683168 U0P=0.018223373455137235 RDSWN=93.542288425672666 RDSWP=127.92931514004974 VSATN=84036.311453537142 VSATP=74656.748434186782 ETA0N=0.074654595759875 ETA0P=0.081027372499812969 WS0=1.0638044565281788 WS1=0.98555728360768313 WS2=0.99322107469658094 WS3=0.92630331735328431
.alter p000138
.param VTHN=0.4243592480073729 VTHP=-0.45919563611502989 U0N=0.050808039599826958 U0P=0.018691454419633803 RDSWN=93.443015090170263 RDSWP=129.25474872788769 VSATN=83616.117135979701 VSATP=78348.618981498381 ETA0N=0.082867912783648481 ETA0P=0.086951155841570385 WS0=1.0659771752192544 WS1=0.91091303718041017 WS2=1.0194514508639598 WS3=1.004152144977716
.alter p000139
.param VTHN=0.47158982320549581 VTHP=-0.44656355389257973 U0N=0.054018176802996566 U0P=0.018620236906683435 RDSWN=101.68905373551078 RDSWP=115.7099850293033 VSATN=74593.447855508173 VSATP=80114.550661414134 ETA0N=0.080343311417618107 ETA0P=0.081325242235887787 WS0=1.0106406409469681 WS1=1.0096760013104609 WS2=0.91138743546122236 WS3=1.0384157019921973
.alter p000140
.param VTHN=0.44838519273616478 VTHP=-0.43788768273877104 U0N=0.048069760407468992 U0P=0.018967865983360279 RDSWN=91.186446693588735 RDSWP=116.73732278905449 VSATN=79656.745033684332 VSATP=82580.506667551352 ETA0N=0.081486454333846103 ETA0P=0.075057655615347704 WS0=0.98170748601542068 WS1=1.047844802024503 WS2=0.94025549317054979 WS3=0.97292657469380794
.alter p000141
.param VTHN=0.44668328859530165 VTHP=-0.47651001093858608 U0N=0.053133741264101753 U0P=0.021453023016212366 RDSWN=106.00751484132994 RDSWP=108.05057150015158 VSATN=86536.382713654966 VSATP=87100.99564635061 ETA0N=0.08379752902320757 ETA0P=0.072247275684259149 WS0=1.070196662163575 WS1=0.92488423745851056 WS2=1.0558987370258801 WS3=1.0610659055987275
.alter p000142
.param VTHN=0.47929854594159643 VTHP=-0.43955449786189132 U0N=0.045082330787871876 U0P=0.019976933580454062 RDSWN=103.43017350312758 RDSWP=115.54534594839996 VSATN=80775.431017376177 VSATP=87172.411758431219 ETA0N=0.073696343312913762 ETA0P=0.074988652844178952 WS0=1.0407660643554604 WS1=1.0710029353097323 WS2=0.90556937745096933 WS3=1.0208800688710613
.alter p000143
.param VTHN=0.47579217903361004 VTHP=-0.44598782138573967 U0N=0.051051151555752398 U0P=0.020160197384603559 RDSWN=96.466293719278212 RDSWP=124.30504742354137 VSATN=85794.269151609711 VSATP=85721.550883433461 ETA0N=0.081173512011699339 ETA0P=0.077560656702119105 WS0=1.0644948386398188 WS1=0.9469509650500948 WS2=0.98687488554312031 WS3=1.030074957330102
.alter p000144
.param VTHN=0.45329343289203355 VTHP=-0.43112005960457955 U0N=0.047102046488187152 U0P=0.020053599433741021 RDSWN=96.326397628775155 RDSWP=111.1112368272637 VSATN=80888.828091115749 VSATP=74728.849652179997 ETA0N=0.073929097126432225 ETA0P=0.073152096175430795 WS0=0.90291247745996095 WS1=0.9363327393593881 WS2=0.99945929241786202 WS3=0.96507298803008812
.alter p000145
.param VTHN=0.43508556290302841 VTHP=-0.46600511296804265 U0N=0.050152918730477766 U0P=0.021919764130151415 RDSWN=105.29790706026331 RDSWP=118.74938215733157 VSATN=77356.070550176097 VSATP=85858.918554759221 ETA0N=0.072670089749718725 ETA0P=0.078872689799902654 WS0=1.0470408334789014 WS1=0.94661824620302448 WS2=1.0780872411558744 WS3=1.0421493959858652
.alter p000146
.param VTHN=0.42265122188667442 VTHP=-0.43496729683312285 U0N=0.046956004830384895 U0P=0.019155340110545285 RDSWN=102.81501325583311 RDSWP=122.29144220568736 VSATN=85534.762408325434 VSATP=78714.363890951834 ETA0N=0.08559861228739854 ETA0P=0.079907300877422108 WS0=0.95199919113421683 WS1=1.0129342620338402 WS2=0.94218626867159361 WS3=0.91794525796764825
.alter p000147
.param VTHN=0.42545323701159254 VTHP=-0.45077021136261641 U0N=0.054951738463788896 U0P=0.021718591275838271 RDSWN=95.817609429112011 RDSWP=117.82327893515104 VSATN=79203.509607892585 VSATP=74188.727084247017 ETA0N=0.084031872301312635 ETA0P=0.087560216978702171 WS0=1.0384816076503409 WS1=1.020938394068156 WS2=0.94715897748833811 WS3=1.0684781428314942
.alter p000148
.param VTHN=0.44309106147975247 VTHP=-0.42967501238157063 U0N=0.046193423016349877 U0P=0.020233660816083465 RDSWN=104.48270719521315 RDSWP=112.16281794017064 VSATN=83241.793742570095 VSATP=84517.346900986246 ETA0N=0.087116355173814539 ETA0P=0.087744990138671902 WS0=1.04783421537468 WS1=0.94150696398492761 WS2=0.94174210319769702 WS3=0.98573580362928526
.alter p000149
.param VTHN=0.478669169804951 VTHP=-0.45801852788351693 U0N=0.048014157590632593 U0P=0.018916615425889405 RDSWN=92.288685801238785 RDSWP=126.29466609624566 VSATN=81950.919611637495 VSATP=72969.324601861736 ETA0N=0.081357247380292902 ETA0P=0.081063078060546079 WS0=0.99708720280715868 WS1=0.97470779918404948 WS2=0.96967988432995811 WS3=1.0725216093477554
.alter p000150
.param VTHN=0.45695522394182708 VTHP=-0.46062558268533638 U0N=0.047079948157201276 U0P=0.018032720049011856 RDSWN=101.95762531358979 RDSWP=122.59924546601724 VSATN=79541.659986434432 VSATP=87627.73276218379 ETA0N=0.078047973341639945 ETA0P=0.077933911607219658 WS0=1.0653279554504829 WS1=1.0202679226714386 WS2=0.91921444095622928 WS3=0.91999141753355973
.alter p000151
.param VTHN=0.46206717820641241 VTHP=-0.47878648264629631 U0N=0.049379006607444625 U0P=0.019968279219980616 RDSWN=95.635829761708962 RDSWP=126.21100729078969 VSATN=76793.130375437599 VSATP=74285.121563081309 ETA0N=0.075423895196921664 ETA0P=0.074135994020639862 WS0=0.94579055566300241 WS1=0.93344839191592233 WS2=1.0930132774627768 WS3=1.0277914070227603
.alter p000152
.param VTHN=0.44059438622733327 VTHP=-0.42125034068224837 U0N=0.049284075221826706 U0P=0.020034252491347174 RDSWN=94.519018469837476 RDSWP=111.92017798945557 VSATN=81796.295155139436 VSATP=73544.630970265513 ETA0N=0.073562671007402339 ETA0P=0.085063009390696609 WS0=0.91192310192360149 WS1=1.0963141567574572 WS2=0.96412660648588044 WS3=1.0762528172831975
.alter p000153
.param VTHN=0.44331717165935092 VTHP=-0.44942910151624932 U0N=0.054662482726699102 U0P=0.020142181167747825 RDSWN=105.13662637628646 RDSWP=125.73377836373075 VSATN=82577.847402171101 VSATP=83177.936248173719 ETA0N=0.081800721062709289 ETA0P=0.08376628098242675 WS0=1.0340875710347077 WS1=1.0893253469495594 WS2=0.93039546797928285 WS3=0.99650214998509457
.alter p000154
.param VTHN=0.46134046245537563 VTHP=-0.44122652559905284 U0N=0.045955358765141091 U0P=0.021895636791233981 RDSWN=95.858914821939166 RDSWP=110.34443315504016 VSATN=76549.252757988404 VSATP=84768.463971168807 ETA0N=0.086734284752401442 ETA0P=0.075382121053564857 WS0=1.0868044246558839 WS1=1.0464936249837444 WS2=1.0919433453724123 WS3=0.94755656610807693
.alter p000155
.param VTHN=0.44714821986705777 VTHP=-0.430225226519791 U0N=0.053703196560468569 U0P=0.018793250231680832 RDSWN=96.28126491528154 RDSWP=114.07725835470798 VSATN=83010.486627566628 VSATP=72316.671798468451 ETA0N=0.076603563000008673 ETA0P=0.073455781927992236 WS0=1.0151703639015515 WS1=0.95847405432190425 WS2=1.0588306563348313 WS3=1.0885342798984239
.alter p000156
.param VTHN=0.42815431485917621 VTHP=-0.46118611628227041 U0N=0.04826882108990866 U0P=0.019520928548480591 RDSWN=104.06640271776095 RDSWP=130.57147342303176 VSATN=73132.473824361427 VSATP=87505.368551568157 ETA0N=0.085246467767982823 ETA0P=0.080636923318654963 WS0=0.90496694061853977 WS1=1.0274030688437326 WS2=1.0346861380893921 WS3=1.086212257020309
.alter p000157
.param VTHN=0.42741786818329597 VTHP=-0.47696355783126398 U0N=0.054608400199480392 U0P=0.019009101400241316 RDSWN=93.075906705785627 RDSWP=124.78354830913763 VSATN=72251.012332810642 VSATP=81668.926146609549 ETA0N=0.086280641223668408 ETA0P=0.073413942544454783 WS0=0.92763732392337084 WS1=0.93178375285636705 WS2=1.0805873448852394 WS3=0.96457131078006519
.alter p000158
.param VTHN=0.46378767121274028 VTHP=-0.4576091394002974 U0N=0.053422613043854546 U0P=0.021938330534230881 RDSWN=98.348304876440523 RDSWP=110.44591208360816 VSATN=80653.515412323759 VSATP=79479.029694353347 ETA0N=0.075196006043296806 ETA0P=0.079486385597751272 WS0=0.96018752335227364 WS1=1.0593142420462134 WS2=0.98676595511155507 WS3=1.08160972930716
.alter p000159
.param VTHN=0.42185165404734076 VTHP=-0.47900839632167402 U0N=0.046659035872299831 U0P=0.021058509853734909 RDSWN=100.3015510681014 RDSWP=117.06460693900378 VSATN=80141.905545961359 VSATP=73052.757848673369 ETA0N=0.086989906342393009 ETA0P=0.079265121447342796 WS0=1.0855002190012331 WS1=0.9654763727684772 WS2=0.97149491071889571 WS3=1.0955154722788436
.alter p000160
.param VTHN=0.47837163841410368 VTHP=-0.46171230004630603 U0N=0.045122898143027626 U0P=0.021525806057389005 RDSWN=90.988752652658263 RDSWP=123.89903453940822 VSATN=85317.305719436656 VSATP=81795.800642458533 ETA0N=0.075587585879130947 ETA0P=0.080999790866408267 WS0=1.0021701865286721 WS1=0.95676046489859046 WS2=1.0625420555441778 WS3=0.94391602325078239
.alter p000161
.param VTHN=0.47747085323983829 VTHP=-0.47210536338747705 U0N=0.046423786313156343 U0P=0.02028265620156228 RDSWN=101.32673165192303 RDSWP=126.04917359283297 VSATN=74711.133448677851 VSATP=78915.915664311862 ETA0N=0.078244908710399824 ETA0P=0.083378784099661887 WS0=1.0551072204142102 WS1=1.0404862700508113 WS2=1.0033549741969769 WS3=1.0281253040946734
.alter p000162
.param VTHN=0.42914226157881086 VTHP=-0.42829012747309042 U0N=0.048120676489071111 U0P=0.021303149530012531 RDSWN=94.279852231443101 RDSWP=129.10598007211175 VSATN=75945.961778470955 VSATP=84080.009276352823 ETA0N=0.073636518795162323 ETA0P=0.086853546174120555 WS0=0.98667057637570477 WS1=1.0294819521203027 WS2=0.9065300761019548 WS3=1.0849959902853921
.alter p000163
.param VTHN=0.45069891850966209 VTHP=-0.4485135802050253 U0N=0.051476749945055036 U0P=0.018625190669169185 RDSWN=98.028222031585187 RDSWP=124.49966831446653 VSATN=79563.594834301315 VSATP=72340.145561101628 ETA0N=0.081280391609963198 ETA0P=0.07761834230917708 WS0=1.000583602392455 WS1=0.99538249108980759 WS2=1.0082318169305229 WS3=0.99252499931801796
.alter p000164
.param VTHN=0.43628338650953091 VTHP=-0.42626960586937823 U0N=0.049794826624813479 U0P=0.020658532101523824 RDSWN=105.4368014956025 RDSWP=123.50442368982087 VSATN=75807.721679742783 VSATP=75043.971371754771 ETA0N=0.072078588844183139 ETA0P=0.078880137708513515 WS0=1.0623033825557742 WS1=0.91929526138961914 WS2=0.99053058591827181 WS3=0.91599389053310221
.alter p000165
.param VTHN=0.46771874546734044 VTHP=-0.44065359764594125 U0N=0.046589011066395729 U0P=0.019829219559140646 RDSWN=102.31310112877023 RDSWP=119.32272877865248 VSATN=77476.308069681021 VSATP=77652.96665213356 ETA0N=0.080893823556558206 ETA0P=0.075565275628822065 WS0=0.90911457232173121 WS1=1.0453482347419902 WS2=0.92470827252282384 WS3=0.91605538958244959
.alter p000166
.param VTHN=0.43913161418806596 VTHP=-0.4533999282897842 U0N=0.05251242923236682 U0P=0.021582960142943433 RDSWN=98.267254381703509 RDSWP=122.83674866355686 VSATN=87385.585567954768 VSATP=75882.700742797853 ETA0N=0.083076842496178652 ETA0P=0.079169169078265475 WS0=1.0823151598135712 WS1=0.94508029040879693 WS2=0.95916565537632492 WS3=1.0263089631040072
.alter p000167
.param VTHN=0.45932052907966697 VTHP=-0.42332967667742755 U0N=0.048791509484357495 U0P=0.01960019317267412 RDSWN=91.764968194529445 RDSWP=127.80997751608516 VSATN=81481.238798712511 VSATP=78891.960421211537 ETA0N=0.080690578744063504 ETA0P=0.075085664468098945 WS0=0.94540502345686428 WS1=0.94938684852086541 WS2=0.93285251543989356 WS3=1.0187299137762755
.alter p000168
.param VTHN=0.45259995425599919 VTHP=-0.4342493502599461 U0N=0.045319971289630202 U0P=0.021964615544090398 RDSWN=93.928083225565331 RDSWP=125.96201080685184 VSATN=78722.242350853368 VSATP=73273.583238891311 ETA0N=0.081140589185689338 ETA0P=0.082761989339837486 WS0=0.94825751923320434 WS1=1.0472611250910719 WS2=0.91083107094149951 WS3=1.0810193397332679
.alter p000169
.param VTHN=0.44381491825616426 VTHP=-0.45293550080060696 U0N=0.048615395573029338 U0P=0.021908743608858163 RDSWN=109.49769248479316 RDSWP=114.41312292674606 VSATN=80287.239104265012 VSATP=75632.00713321229 ETA0N=0.082316071219227169 ETA0P=0.08452498891514966 WS0=1.0297194916401402 WS1=0.9158033120329665 WS2=0.98111866649116153 WS3=0.92435482874529418
.alter p000170
.param VTHN=0.44418835123482409 VTHP=-0.4233645209964903 U0N=0.051517026971299285 U0P=0.021315810046712562 RDSWN=103.72630412903567 RDSWP=111.72855159412413 VSATN=81832.760356367449 VSATP=74345.291169792836 ETA0N=0.077488497441445869 ETA0P=0.073220782261735146 WS0=0.91111155408916755 WS1=1.0749864906350204 WS2=0.97305142003409006 WS3=1.0938300046498595
.alter p000171
.param VTHN=0.45295465661631051 VTHP=-0.4393911863365888 U0N=0.050867943578933573 U0P=0.019673314880561555 RDSWN=109.53601044034916 RDSWP=117.549295041997 VSATN=83458.044916208892 VSATP=84709.896385256259 ETA0N=0.085730302983474047 ETA0P=0.080039736688533716 WS0=1.091311017554337 WS1=0.97248126286635239 WS2=1.0818449381571376 WS3=1.0710949851711213
.alter p000172
.param VTHN=0.46903370560882923 VTHP=-0.47813401107569597 U0N=0.050775572821027008 U0P=0.020579482384911755 RDSWN=108.85961874108102 RDSWP=131.88977940208736 VSATN=86689.981933061295 VSATP=83490.906425748632 ETA0N=0.079051735275071727 ETA0P=0.075357584843960074 WS0=0.93149128525113722 WS1=1.0955757781382589 WS2=1.0573927531808127 WS3=1.0942959895966031
.alter p000173
.param VTHN=0.47538542077443552 VTHP=-0.44860427703558403 U0N=0.049642522813002563 U0P=0.021902378396307244 RDSWN=96.133083291460821 RDSWP=109.57494878116943 VSATN=81654.026310359244 VSATP=80737.262488596636 ETA0N=0.079032964737217437 ETA0P=0.079834344946433239 WS0=1.033794037600098 WS1=1.0321842611864114 WS2=1.0621834293360983 WS3=0.95004407466407437
.alter p000174
.param VTHN=0.4444841498981581 VTHP=-0.46232330548027567 U0N=0.046965733628338037 U0P=0.019720503060720589 RDSWN=109.35959531169838 RDSWP=109.90885469523788 VSATN=77909.690654996477 VSATP=77139.84947338968 ETA0N=0.084784822579122857 ETA0P=0.072744393216785996 WS0=1.076681359907314 WS1=1.0835483709767273 WS2=1.0664362622184362 WS3=1.0553385972797569
.alter p000175
.param VTHN=0.4519042830322339 VTHP=-0.45675505929725768 U0N=0.051600624944143865 U0P=0.020205519530405162 RDSWN=101.25443622534515 RDSWP=123.75254193626486 VSATN=74103.104794686835 VSATP=75601.982460984233 ETA0N=0.073490971192685203 ETA0P=0.077363903946620433 WS0=1.0014126771045353 WS1=0.9210173407197606 WS2=0.96677907757341519 WS3=0.94214326116146185
.alter p000176
.param VTHN=0.47558663360864384 VTHP=-0.4304524645973109 U0N=0.053963723131979141 U0P=0.021487440600750439 RDSWN=101.41752524032979 RDSWP=115.03218223081511 VSATN=76889.30657916193 VSATP=73137.286054904107 ETA0N=0.078138694403183315 ETA0P=0.076049681437552419 WS0=0.90938871796000142 WS1=0.90472173296404601 WS2=0.95321624475428435 WS3=1.0213889592520722
.alter p000177
.param VTHN=0.47063345832133413 VTHP=-0.42449597639257608 U0N=0.047590617284636587 U0P=0.01961674024635511 RDSWN=106.20440041346889 RDSWP=118.4874585019905 VSATN=77174.072210201033 VSATP=82357.294393243428 ETA0N=0.072869761324786217 ETA0P=0.07935779166735614 WS0=0.91609101269023441 WS1=0.93386738418579307 WS2=0.93966743996296231 WS3=0.9554921239688321
.alter p000178
.param VTHN=0.45355605657969211 VTHP=-0.42924442484017955 U0N=0.047260357023479596 U0P=0.01877462706653113 RDSWN=98.531618544538475 RDSWP=125.36984116192939 VSATN=72423.641685125505 VSATP=76197.206694245746 ETA0N=0.075648711596103965 ETA0P=0.086442391177065994 WS0=0.97396376922790506 WS1=1.0353798291328171 WS2=1.0943999592990079 WS3=0.95671857427375984
.alter p000179
.param VTHN=0.43760315789779686 VTHP=-0.47835085486989104 U0N=0.045435342063334973 U0P=0.021512359808283664 RDSWN=93.38514401643603 RDSWP=112.25874153460538 VSATN=83586.995777311487 VSATP=82472.792959880186 ETA0N=0.079430306103298792 ETA0P=0.078577729444542277 WS0=1.0493818370367745 WS1=1.0941860045409619 WS2=1.0870406875163057 WS3=1.0030176376244742
.alter p000180
.param VTHN=0.46224302604571349 VTHP=-0.42441363714804942 U0N=0.046111111430003689 U0P=0.01994700618700777 RDSWN=91.050422656397586 RDSWP=113.12633796207612 VSATN=75341.976786238607 VSATP=81728.56465896836 ETA0N=0.080167264779892472 ETA0P=0.083159792375534544 WS0=1.059861098193603 WS1=1.0821984295517806 WS2=0.93178848693828575 WS3=1.0894162314902001
.alter p000181
.param VTHN=0.46619724853490291 VTHP=-0.46377369467598517 U0N=0.052898948618940136 U0P=0.021757362694745718 RDSWN=92.084168378209185 RDSWP=112.61647227478562 VSATN=72907.890349415611 VSATP=81306.407559999134 ETA0N=0.072022787624669168 ETA0P=0.083435354935416317 WS0=0.95137871929708973 WS1=0.91291066550499733 WS2=0.98233268559109455 WS3=0.99225497884381098
.alter p000182
.param VTHN=0.43425208751716726 VTHP=-0.462987380997673 U0N=0.049048252496368822 U0P=0.021988298980415988 RDSWN=91.938951977473394 RDSWP=127.27932452133274 VSATN=79294.162811581875 VSATP=75729.149420692149 ETA0N=0.084143887456953434 ETA0P=0.072528198273835318 WS0=1.0919302598173923 WS1=1.0222488546680948 WS2=1.0543732137466411 WS3=1.0181245763728062
.alter p000183
.param VTHN=0.43124230950752535 VTHP=-0.46414093338593121 U0N=0.045369679584644274 U0P=0.020494009224751128 RDSWN=92.667208517035903 RDSWP=110.02661112582199 VSATN=79967.238997953507 VSATP=77920.721785133937 ETA0N=0.072063921638899006 ETA0P=0.075392225335019353 WS0=0.91058558531011824 WS1=0.94634655661187295 WS2=1.009184839858331 WS3=0.9551758164754377
.alter p000184
.param VTHN=0.47027523121917991 VTHP=-0.46359626381963642 U0N=0.052867519546147969 U0P=0.020899233491898959 RDSWN=104.35144801365058 RDSWP=117.89248762351548 VSATN=85649.720148734559 VSATP=72376.186475965194 ETA0N=0.075346945367238405 ETA0P=0.077854873628283014 WS0=0.96802553530362834 WS1=1.0432928784368556 WS2=1.070881288216744 WS3=0.95044238788393742
.alter p000185
.param VTHN=0.46071820865405089 VTHP=-0.42951089600949988 U0N=0.052611947707951544 U0P=0.020066207905870888 RDSWN=108.13929029028424 RDSWP=120.73091118595241 VSATN=75054.867995977227 VSATP=85222.030567308073 ETA0N=0.08582724351781211 ETA0P=0.084983278146194649 WS0=0.93087262364560452 WS1=1.0903205055989562 WS2=0.99804110127900292 WS3=0.95356731847953202
.alter p000186
.param VTHN=0.46740180140469606 VTHP=-0.46664884362881087 U0N=0.054337818847752364 U0P=0.020522230814974739 RDSWN=106.68896861525414 RDSWP=119.01033053342054 VSATN=72884.485188149803 VSATP=83717.412891547312 ETA0N=0.086202756410647022 ETA0P=0.080382536336362553 WS0=0.97434044802433273 WS1=0.96588156351593391 WS2=1.0332483427833168 WS3=0.95262264426292276
.alter p000187
.param VTHN=0.42967690283060223 VTHP=-0.46249022282078595 U0N=0.054414466691389558 U0P=0.019285015297974651 RDSWN=91.854757980100729 RDSWP=124.81076598549355 VSATN=87180.236618495546 VSATP=80142.731738724338 ETA0N=0.082502375160679264 ETA0P=0.084013683151003327 WS0=0.9076025459113749 WS1=0.97032370345114016 WS2=0.91510715690599775 WS3=1.0417424358784695
.alter p000188
.param VTHN=0.44528901177328711 VTHP=-0.42105432112724378 U0N=0.052189222302123986 U0P=0.020470031978849442 RDSWN=108.615692043525 RDSWP=111.65199521402404 VSATN=86148.80027699341 VSATP=75298.130697082684 ETA0N=0.084869576533311453 ETA0P=0.079594391621418376 WS0=1.0430311598387922 WS1=1.0115579199795581 WS2=0.90860633380748568 WS3=0.96783890476409884
.alter p000189
.param VTHN=0.4713377517726704 VTHP=-0.44135638571384872 U0N=0.053788256564213065 U0P=0.020254047114140767 RDSWN=94.050346416596057 RDSWP=114.16674686930925 VSATN=77611.488924496647 VSATP=77760.541222712447 ETA0N=0.081958654518663229 ETA0P=0.087193805365793062 WS0=1.0662179171867086 WS1=0.9067870293071163 WS2=0.96841771248427899 WS3=0.96824933119357104
.alter p000190
.param VTHN=0.46664992284952034 VTHP=-0.44380036167387638 U0N=0.052472798763690633 U0P=0.020719334888811537 RDSWN=105.9901382796407 RDSWP=109.30512719936691 VSATN=76392.950815301039 VSATP=74313.46349232264 ETA0N=0.074880264231028948 ETA0P=0.086805641395224467 WS0=0.97674848393432623 WS1=1.0501005493401214 WS2=1.0242289725408378 WS3=1.0510417362865909
.alter p000191
.param VTHN=0.47065999258774194 VTHP=-0.42387278111264282 U0N=0.046305432536446429 U0P=0.020454410843047392 RDSWN=90.82261252224599 RDSWP=131.83718142707207 VSATN=82255.548724621432 VSATP=85331.276576891833 ETA0N=0.079276006253175615 ETA0P=0.076745009581642792 WS0=0.91379651488896818 WS1=1.0436985921063084 WS2=1.0833817533931187 WS3=1.0292564195635707
.alter p000192
.param VTHN=0.43968716593356555 VTHP=-0.42918206177344215 U0N=0.054823486288156885 U0P=0.020442843507944126 RDSWN=107.03760664662337 RDSWP=125.79800135860314 VSATN=73809.894411605463 VSATP=73468.573671375343 ETA0N=0.081256546834124949 ETA0P=0.086984847625946007 WS0=0.95997906251410869 WS1=0.98798168757986882 WS2=0.94144472890851383 WS3=1.0117013560241195
.alter p000193
.param VTHN=0.43161096340810001 VTHP=-0.4367086533956423 U0N=0.050610594236170946 U0P=0.021494906606230227 RDSWN=97.016914755712691 RDSWP=116.23779897703973 VSATN=74795.783621657451 VSATP=82453.6915800813 ETA0N=0.084381060873874897 ETA0P=0.07875681393215396 WS0=0.96701400779733959 WS1=1.0734917181650967 WS2=0.95380416529722967 WS3=1.025632218328514
.alter p000194
.param VTHN=0.46484938649171209 VTHP=-0.47737378923671103 U0N=0.045605332275715858 U0P=0.02024473175091206 RDSWN=95.460010838756347 RDSWP=122.76522651918388 VSATN=86805.944573483197 VSATP=84162.486498349463 ETA0N=0.078634725773276709 ETA0P=0.081270165612849291 WS0=0.92475869910342956 WS1=0.96496394217125592 WS2=1.079741528331279 WS3=1.0585019129343838
.alter p000195
.param VTHN=0.42386528597271217 VTHP=-0.46074533528524497 U0N=0.047658365141519124 U0P=0.018977488899683075 RDSWN=107.70049558131296 RDSWP=119.56529590357265 VSATN=78856.358055092394 VSATP=77211.792682259169 ETA0N=0.076017038116194188 ETA0P=0.083613121611898211 WS0=1.0216889078787614 WS1=0.9983381206804558 WS2=0.93697594284561203 WS3=1.0825569700854594
.alter p000196
.param VTHN=0.44295793060353178 VTHP=-0.44185189274468351 U0N=0.047849038179525849 U0P=0.021441596751252213 RDSWN=90.861735537367579 RDSWP=127.60251761920958 VSATN=87534.9416910953 VSATP=83218.230273644906 ETA0N=0.087222622441528008 ETA0P=0.08666804033787788 WS0=1.0432907933164957 WS1=0.94777716123339906 WS2=0.96898141487818135 WS3=0.94917939126599649
.alter p000197
.param VTHN=0.45836145988733784 VTHP=-0.44233584048597008 U0N=0.051797739062309424 U0P=0.020826400760264149 RDSWN=98.112328027188894 RDSWP=117.23552832330054 VSATN=85753.86327858537 VSATP=72161.55804130972 ETA0N=0.0793701637115036 ETA0P=0.081686597376114611 WS0=0.94701152156131441 WS1=1.0127366115698979 WS2=1.0167787516667079 WS3=0.97681105415012015
.alter p000198
.param VTHN=0.47001378288285328 VTHP=-0.44895199860429186 U0N=0.048227652685226163 U0P=0.021429052732816273 RDSWN=94.211470239499747 RDSWP=108.20764165958199 VSATN=87340.727540438267 VSATP=87250.058745567498 ETA0N=0.079898275975263555 ETA0P=0.075846042098386621 WS0=1.0538374330698883 WS1=1.0997062148876195 WS2=1.0013833225759601 WS3=1.0612696939225756
.alter p000199
.param VTHN=0.42222795132318053 VTHP=-0.44329534080639238 U0N=0.045851068505621033 U0P=0.019578916895318432 RDSWN=109.66461400346569 RDSWP=120.40656723823179 VSATN=76989.764872856947 VSATP=79092.819041620329 ETA0N=0.072764509830903726 ETA0P=0.081815489473595168 WS0=0.98746887704765218 WS1=0.96866792942156477 WS2=0.94616206300482575 WS3=0.94412490200955623
.end
