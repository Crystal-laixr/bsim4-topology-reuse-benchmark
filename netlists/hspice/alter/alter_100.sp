* 550-MOS BSIM4 HSPICE alter benchmark
.option nomod reltol=1e-6 vntol=1e-9 abstol=1e-15
.temp 25
.param VTHN=0.45126483051096039 VTHP=-0.43712328775058912 U0N=0.054472227924512562 U0P=0.019642227633496968 RDSWN=95.093588416662513 RDSWP=125.06632680402315 VSATN=87504.447322012653 VSATP=75147.443178696412 ETA0N=0.086119024107108172 ETA0P=0.072375500135660659 WS0=0.9297506302192986 WS1=1.0376459501931772 WS2=0.95303198059391914 WS3=1.02285909173834
.model NM NMOS LEVEL=54 VERSION=4.7.0 TOXE=1.5n XJ=0.1u NDEP=1.7e17 VTH0='VTHN' U0='U0N' RDSW='RDSWN' VSAT='VSATN' ETA0='ETA0N'
.model PM PMOS LEVEL=54 VERSION=4.7.0 TOXE=1.5n XJ=0.1u NDEP=1.2e17 VTH0='VTHP' U0='U0P' RDSW='RDSWP' VSAT='VSATP' ETA0='ETA0P'
VDD vdd 0 1.8
VIN in 0 0
MN_L01_S01 l01_n01 in 0 0 NM W='1.5199999999999998e-06*WS0' L=0.18u
MP_L01_S01 l01_n01 in vdd vdd PM W='3.0399999999999997e-06*WS0' L=0.18u
MN_L01_S02 l01_n02 l01_n01 0 0 NM W='2.2800000000000002e-06*WS1' L=0.18u
MP_L01_S02 l01_n02 l01_n01 vdd vdd PM W='4.5600000000000004e-06*WS1' L=0.18u
MN_L01_S03 l01_n03 l01_n02 0 0 NM W='3.4200000000000003e-06*WS2' L=0.18u
MP_L01_S03 l01_n03 l01_n02 vdd vdd PM W='6.8400000000000006e-06*WS2' L=0.18u
MN_L01_S04 l01_n04 l01_n03 0 0 NM W='5.13e-06*WS3' L=0.18u
MP_L01_S04 l01_n04 l01_n03 vdd vdd PM W='1.026e-05*WS3' L=0.18u
MN_L01_S05 l01_n05 l01_n04 0 0 NM W='1.5199999999999998e-06*WS0' L=0.18u
MP_L01_S05 l01_n05 l01_n04 vdd vdd PM W='3.0399999999999997e-06*WS0' L=0.18u
MN_L01_S06 l01_n06 l01_n05 0 0 NM W='2.2800000000000002e-06*WS1' L=0.18u
MP_L01_S06 l01_n06 l01_n05 vdd vdd PM W='4.5600000000000004e-06*WS1' L=0.18u
MN_L01_S07 l01_n07 l01_n06 0 0 NM W='3.4200000000000003e-06*WS2' L=0.18u
MP_L01_S07 l01_n07 l01_n06 vdd vdd PM W='6.8400000000000006e-06*WS2' L=0.18u
MN_L01_S08 l01_n08 l01_n07 0 0 NM W='5.13e-06*WS3' L=0.18u
MP_L01_S08 l01_n08 l01_n07 vdd vdd PM W='1.026e-05*WS3' L=0.18u
MN_L01_S09 l01_n09 l01_n08 0 0 NM W='1.5199999999999998e-06*WS0' L=0.18u
MP_L01_S09 l01_n09 l01_n08 vdd vdd PM W='3.0399999999999997e-06*WS0' L=0.18u
MN_L01_S10 l01_n10 l01_n09 0 0 NM W='2.2800000000000002e-06*WS1' L=0.18u
MP_L01_S10 l01_n10 l01_n09 vdd vdd PM W='4.5600000000000004e-06*WS1' L=0.18u
MN_L01_S11 l01_n11 l01_n10 0 0 NM W='3.4200000000000003e-06*WS2' L=0.18u
MP_L01_S11 l01_n11 l01_n10 vdd vdd PM W='6.8400000000000006e-06*WS2' L=0.18u
RLEAK_L01 l01_n11 0 1g
MN_L02_S01 l02_n01 in 0 0 NM W='1.5599999999999999e-06*WS0' L=0.18u
MP_L02_S01 l02_n01 in vdd vdd PM W='3.1199999999999998e-06*WS0' L=0.18u
MN_L02_S02 l02_n02 l02_n01 0 0 NM W='2.34e-06*WS1' L=0.18u
MP_L02_S02 l02_n02 l02_n01 vdd vdd PM W='4.6800000000000001e-06*WS1' L=0.18u
MN_L02_S03 l02_n03 l02_n02 0 0 NM W='3.5100000000000003e-06*WS2' L=0.18u
MP_L02_S03 l02_n03 l02_n02 vdd vdd PM W='7.0200000000000006e-06*WS2' L=0.18u
MN_L02_S04 l02_n04 l02_n03 0 0 NM W='5.2649999999999996e-06*WS3' L=0.18u
MP_L02_S04 l02_n04 l02_n03 vdd vdd PM W='1.0529999999999999e-05*WS3' L=0.18u
MN_L02_S05 l02_n05 l02_n04 0 0 NM W='1.5599999999999999e-06*WS0' L=0.18u
MP_L02_S05 l02_n05 l02_n04 vdd vdd PM W='3.1199999999999998e-06*WS0' L=0.18u
MN_L02_S06 l02_n06 l02_n05 0 0 NM W='2.34e-06*WS1' L=0.18u
MP_L02_S06 l02_n06 l02_n05 vdd vdd PM W='4.6800000000000001e-06*WS1' L=0.18u
MN_L02_S07 l02_n07 l02_n06 0 0 NM W='3.5100000000000003e-06*WS2' L=0.18u
MP_L02_S07 l02_n07 l02_n06 vdd vdd PM W='7.0200000000000006e-06*WS2' L=0.18u
MN_L02_S08 l02_n08 l02_n07 0 0 NM W='5.2649999999999996e-06*WS3' L=0.18u
MP_L02_S08 l02_n08 l02_n07 vdd vdd PM W='1.0529999999999999e-05*WS3' L=0.18u
MN_L02_S09 l02_n09 l02_n08 0 0 NM W='1.5599999999999999e-06*WS0' L=0.18u
MP_L02_S09 l02_n09 l02_n08 vdd vdd PM W='3.1199999999999998e-06*WS0' L=0.18u
MN_L02_S10 l02_n10 l02_n09 0 0 NM W='2.34e-06*WS1' L=0.18u
MP_L02_S10 l02_n10 l02_n09 vdd vdd PM W='4.6800000000000001e-06*WS1' L=0.18u
MN_L02_S11 l02_n11 l02_n10 0 0 NM W='3.5100000000000003e-06*WS2' L=0.18u
MP_L02_S11 l02_n11 l02_n10 vdd vdd PM W='7.0200000000000006e-06*WS2' L=0.18u
RLEAK_L02 l02_n11 0 1g
MN_L03_S01 l03_n01 in 0 0 NM W='1.5999999999999999e-06*WS0' L=0.18u
MP_L03_S01 l03_n01 in vdd vdd PM W='3.1999999999999999e-06*WS0' L=0.18u
MN_L03_S02 l03_n02 l03_n01 0 0 NM W='2.4000000000000003e-06*WS1' L=0.18u
MP_L03_S02 l03_n02 l03_n01 vdd vdd PM W='4.8000000000000006e-06*WS1' L=0.18u
MN_L03_S03 l03_n03 l03_n02 0 0 NM W='3.6000000000000003e-06*WS2' L=0.18u
MP_L03_S03 l03_n03 l03_n02 vdd vdd PM W='7.2000000000000005e-06*WS2' L=0.18u
MN_L03_S04 l03_n04 l03_n03 0 0 NM W='5.4e-06*WS3' L=0.18u
MP_L03_S04 l03_n04 l03_n03 vdd vdd PM W='1.08e-05*WS3' L=0.18u
MN_L03_S05 l03_n05 l03_n04 0 0 NM W='1.5999999999999999e-06*WS0' L=0.18u
MP_L03_S05 l03_n05 l03_n04 vdd vdd PM W='3.1999999999999999e-06*WS0' L=0.18u
MN_L03_S06 l03_n06 l03_n05 0 0 NM W='2.4000000000000003e-06*WS1' L=0.18u
MP_L03_S06 l03_n06 l03_n05 vdd vdd PM W='4.8000000000000006e-06*WS1' L=0.18u
MN_L03_S07 l03_n07 l03_n06 0 0 NM W='3.6000000000000003e-06*WS2' L=0.18u
MP_L03_S07 l03_n07 l03_n06 vdd vdd PM W='7.2000000000000005e-06*WS2' L=0.18u
MN_L03_S08 l03_n08 l03_n07 0 0 NM W='5.4e-06*WS3' L=0.18u
MP_L03_S08 l03_n08 l03_n07 vdd vdd PM W='1.08e-05*WS3' L=0.18u
MN_L03_S09 l03_n09 l03_n08 0 0 NM W='1.5999999999999999e-06*WS0' L=0.18u
MP_L03_S09 l03_n09 l03_n08 vdd vdd PM W='3.1999999999999999e-06*WS0' L=0.18u
MN_L03_S10 l03_n10 l03_n09 0 0 NM W='2.4000000000000003e-06*WS1' L=0.18u
MP_L03_S10 l03_n10 l03_n09 vdd vdd PM W='4.8000000000000006e-06*WS1' L=0.18u
MN_L03_S11 l03_n11 l03_n10 0 0 NM W='3.6000000000000003e-06*WS2' L=0.18u
MP_L03_S11 l03_n11 l03_n10 vdd vdd PM W='7.2000000000000005e-06*WS2' L=0.18u
RLEAK_L03 l03_n11 0 1g
MN_L04_S01 l04_n01 in 0 0 NM W='1.64e-06*WS0' L=0.18u
MP_L04_S01 l04_n01 in vdd vdd PM W='3.2799999999999999e-06*WS0' L=0.18u
MN_L04_S02 l04_n02 l04_n01 0 0 NM W='2.4600000000000002e-06*WS1' L=0.18u
MP_L04_S02 l04_n02 l04_n01 vdd vdd PM W='4.9200000000000003e-06*WS1' L=0.18u
MN_L04_S03 l04_n03 l04_n02 0 0 NM W='3.6900000000000002e-06*WS2' L=0.18u
MP_L04_S03 l04_n03 l04_n02 vdd vdd PM W='7.3800000000000005e-06*WS2' L=0.18u
MN_L04_S04 l04_n04 l04_n03 0 0 NM W='5.5350000000000004e-06*WS3' L=0.18u
MP_L04_S04 l04_n04 l04_n03 vdd vdd PM W='1.1070000000000001e-05*WS3' L=0.18u
MN_L04_S05 l04_n05 l04_n04 0 0 NM W='1.64e-06*WS0' L=0.18u
MP_L04_S05 l04_n05 l04_n04 vdd vdd PM W='3.2799999999999999e-06*WS0' L=0.18u
MN_L04_S06 l04_n06 l04_n05 0 0 NM W='2.4600000000000002e-06*WS1' L=0.18u
MP_L04_S06 l04_n06 l04_n05 vdd vdd PM W='4.9200000000000003e-06*WS1' L=0.18u
MN_L04_S07 l04_n07 l04_n06 0 0 NM W='3.6900000000000002e-06*WS2' L=0.18u
MP_L04_S07 l04_n07 l04_n06 vdd vdd PM W='7.3800000000000005e-06*WS2' L=0.18u
MN_L04_S08 l04_n08 l04_n07 0 0 NM W='5.5350000000000004e-06*WS3' L=0.18u
MP_L04_S08 l04_n08 l04_n07 vdd vdd PM W='1.1070000000000001e-05*WS3' L=0.18u
MN_L04_S09 l04_n09 l04_n08 0 0 NM W='1.64e-06*WS0' L=0.18u
MP_L04_S09 l04_n09 l04_n08 vdd vdd PM W='3.2799999999999999e-06*WS0' L=0.18u
MN_L04_S10 l04_n10 l04_n09 0 0 NM W='2.4600000000000002e-06*WS1' L=0.18u
MP_L04_S10 l04_n10 l04_n09 vdd vdd PM W='4.9200000000000003e-06*WS1' L=0.18u
MN_L04_S11 l04_n11 l04_n10 0 0 NM W='3.6900000000000002e-06*WS2' L=0.18u
MP_L04_S11 l04_n11 l04_n10 vdd vdd PM W='7.3800000000000005e-06*WS2' L=0.18u
RLEAK_L04 l04_n11 0 1g
MN_L05_S01 l05_n01 in 0 0 NM W='1.6799999999999998e-06*WS0' L=0.18u
MP_L05_S01 l05_n01 in vdd vdd PM W='3.3599999999999996e-06*WS0' L=0.18u
MN_L05_S02 l05_n02 l05_n01 0 0 NM W='2.52e-06*WS1' L=0.18u
MP_L05_S02 l05_n02 l05_n01 vdd vdd PM W='5.04e-06*WS1' L=0.18u
MN_L05_S03 l05_n03 l05_n02 0 0 NM W='3.7799999999999998e-06*WS2' L=0.18u
MP_L05_S03 l05_n03 l05_n02 vdd vdd PM W='7.5599999999999996e-06*WS2' L=0.18u
MN_L05_S04 l05_n04 l05_n03 0 0 NM W='5.6699999999999999e-06*WS3' L=0.18u
MP_L05_S04 l05_n04 l05_n03 vdd vdd PM W='1.134e-05*WS3' L=0.18u
MN_L05_S05 l05_n05 l05_n04 0 0 NM W='1.6799999999999998e-06*WS0' L=0.18u
MP_L05_S05 l05_n05 l05_n04 vdd vdd PM W='3.3599999999999996e-06*WS0' L=0.18u
MN_L05_S06 l05_n06 l05_n05 0 0 NM W='2.52e-06*WS1' L=0.18u
MP_L05_S06 l05_n06 l05_n05 vdd vdd PM W='5.04e-06*WS1' L=0.18u
MN_L05_S07 l05_n07 l05_n06 0 0 NM W='3.7799999999999998e-06*WS2' L=0.18u
MP_L05_S07 l05_n07 l05_n06 vdd vdd PM W='7.5599999999999996e-06*WS2' L=0.18u
MN_L05_S08 l05_n08 l05_n07 0 0 NM W='5.6699999999999999e-06*WS3' L=0.18u
MP_L05_S08 l05_n08 l05_n07 vdd vdd PM W='1.134e-05*WS3' L=0.18u
MN_L05_S09 l05_n09 l05_n08 0 0 NM W='1.6799999999999998e-06*WS0' L=0.18u
MP_L05_S09 l05_n09 l05_n08 vdd vdd PM W='3.3599999999999996e-06*WS0' L=0.18u
MN_L05_S10 l05_n10 l05_n09 0 0 NM W='2.52e-06*WS1' L=0.18u
MP_L05_S10 l05_n10 l05_n09 vdd vdd PM W='5.04e-06*WS1' L=0.18u
MN_L05_S11 l05_n11 l05_n10 0 0 NM W='3.7799999999999998e-06*WS2' L=0.18u
MP_L05_S11 l05_n11 l05_n10 vdd vdd PM W='7.5599999999999996e-06*WS2' L=0.18u
RLEAK_L05 l05_n11 0 1g
MN_L06_S01 l06_n01 in 0 0 NM W='1.7199999999999998e-06*WS0' L=0.18u
MP_L06_S01 l06_n01 in vdd vdd PM W='3.4399999999999997e-06*WS0' L=0.18u
MN_L06_S02 l06_n02 l06_n01 0 0 NM W='2.5799999999999999e-06*WS1' L=0.18u
MP_L06_S02 l06_n02 l06_n01 vdd vdd PM W='5.1599999999999997e-06*WS1' L=0.18u
MN_L06_S03 l06_n03 l06_n02 0 0 NM W='3.8700000000000002e-06*WS2' L=0.18u
MP_L06_S03 l06_n03 l06_n02 vdd vdd PM W='7.7400000000000004e-06*WS2' L=0.18u
MN_L06_S04 l06_n04 l06_n03 0 0 NM W='5.8049999999999995e-06*WS3' L=0.18u
MP_L06_S04 l06_n04 l06_n03 vdd vdd PM W='1.1609999999999999e-05*WS3' L=0.18u
MN_L06_S05 l06_n05 l06_n04 0 0 NM W='1.7199999999999998e-06*WS0' L=0.18u
MP_L06_S05 l06_n05 l06_n04 vdd vdd PM W='3.4399999999999997e-06*WS0' L=0.18u
MN_L06_S06 l06_n06 l06_n05 0 0 NM W='2.5799999999999999e-06*WS1' L=0.18u
MP_L06_S06 l06_n06 l06_n05 vdd vdd PM W='5.1599999999999997e-06*WS1' L=0.18u
MN_L06_S07 l06_n07 l06_n06 0 0 NM W='3.8700000000000002e-06*WS2' L=0.18u
MP_L06_S07 l06_n07 l06_n06 vdd vdd PM W='7.7400000000000004e-06*WS2' L=0.18u
MN_L06_S08 l06_n08 l06_n07 0 0 NM W='5.8049999999999995e-06*WS3' L=0.18u
MP_L06_S08 l06_n08 l06_n07 vdd vdd PM W='1.1609999999999999e-05*WS3' L=0.18u
MN_L06_S09 l06_n09 l06_n08 0 0 NM W='1.7199999999999998e-06*WS0' L=0.18u
MP_L06_S09 l06_n09 l06_n08 vdd vdd PM W='3.4399999999999997e-06*WS0' L=0.18u
MN_L06_S10 l06_n10 l06_n09 0 0 NM W='2.5799999999999999e-06*WS1' L=0.18u
MP_L06_S10 l06_n10 l06_n09 vdd vdd PM W='5.1599999999999997e-06*WS1' L=0.18u
MN_L06_S11 l06_n11 l06_n10 0 0 NM W='3.8700000000000002e-06*WS2' L=0.18u
MP_L06_S11 l06_n11 l06_n10 vdd vdd PM W='7.7400000000000004e-06*WS2' L=0.18u
RLEAK_L06 l06_n11 0 1g
MN_L07_S01 l07_n01 in 0 0 NM W='1.7599999999999999e-06*WS0' L=0.18u
MP_L07_S01 l07_n01 in vdd vdd PM W='3.5199999999999998e-06*WS0' L=0.18u
MN_L07_S02 l07_n02 l07_n01 0 0 NM W='2.6400000000000001e-06*WS1' L=0.18u
MP_L07_S02 l07_n02 l07_n01 vdd vdd PM W='5.2800000000000003e-06*WS1' L=0.18u
MN_L07_S03 l07_n03 l07_n02 0 0 NM W='3.9600000000000002e-06*WS2' L=0.18u
MP_L07_S03 l07_n03 l07_n02 vdd vdd PM W='7.9200000000000004e-06*WS2' L=0.18u
MN_L07_S04 l07_n04 l07_n03 0 0 NM W='5.9399999999999999e-06*WS3' L=0.18u
MP_L07_S04 l07_n04 l07_n03 vdd vdd PM W='1.188e-05*WS3' L=0.18u
MN_L07_S05 l07_n05 l07_n04 0 0 NM W='1.7599999999999999e-06*WS0' L=0.18u
MP_L07_S05 l07_n05 l07_n04 vdd vdd PM W='3.5199999999999998e-06*WS0' L=0.18u
MN_L07_S06 l07_n06 l07_n05 0 0 NM W='2.6400000000000001e-06*WS1' L=0.18u
MP_L07_S06 l07_n06 l07_n05 vdd vdd PM W='5.2800000000000003e-06*WS1' L=0.18u
MN_L07_S07 l07_n07 l07_n06 0 0 NM W='3.9600000000000002e-06*WS2' L=0.18u
MP_L07_S07 l07_n07 l07_n06 vdd vdd PM W='7.9200000000000004e-06*WS2' L=0.18u
MN_L07_S08 l07_n08 l07_n07 0 0 NM W='5.9399999999999999e-06*WS3' L=0.18u
MP_L07_S08 l07_n08 l07_n07 vdd vdd PM W='1.188e-05*WS3' L=0.18u
MN_L07_S09 l07_n09 l07_n08 0 0 NM W='1.7599999999999999e-06*WS0' L=0.18u
MP_L07_S09 l07_n09 l07_n08 vdd vdd PM W='3.5199999999999998e-06*WS0' L=0.18u
MN_L07_S10 l07_n10 l07_n09 0 0 NM W='2.6400000000000001e-06*WS1' L=0.18u
MP_L07_S10 l07_n10 l07_n09 vdd vdd PM W='5.2800000000000003e-06*WS1' L=0.18u
MN_L07_S11 l07_n11 l07_n10 0 0 NM W='3.9600000000000002e-06*WS2' L=0.18u
MP_L07_S11 l07_n11 l07_n10 vdd vdd PM W='7.9200000000000004e-06*WS2' L=0.18u
RLEAK_L07 l07_n11 0 1g
MN_L08_S01 l08_n01 in 0 0 NM W='1.7999999999999999e-06*WS0' L=0.18u
MP_L08_S01 l08_n01 in vdd vdd PM W='3.5999999999999998e-06*WS0' L=0.18u
MN_L08_S02 l08_n02 l08_n01 0 0 NM W='2.7e-06*WS1' L=0.18u
MP_L08_S02 l08_n02 l08_n01 vdd vdd PM W='5.4e-06*WS1' L=0.18u
MN_L08_S03 l08_n03 l08_n02 0 0 NM W='4.0500000000000002e-06*WS2' L=0.18u
MP_L08_S03 l08_n03 l08_n02 vdd vdd PM W='8.1000000000000004e-06*WS2' L=0.18u
MN_L08_S04 l08_n04 l08_n03 0 0 NM W='6.0750000000000003e-06*WS3' L=0.18u
MP_L08_S04 l08_n04 l08_n03 vdd vdd PM W='1.2150000000000001e-05*WS3' L=0.18u
MN_L08_S05 l08_n05 l08_n04 0 0 NM W='1.7999999999999999e-06*WS0' L=0.18u
MP_L08_S05 l08_n05 l08_n04 vdd vdd PM W='3.5999999999999998e-06*WS0' L=0.18u
MN_L08_S06 l08_n06 l08_n05 0 0 NM W='2.7e-06*WS1' L=0.18u
MP_L08_S06 l08_n06 l08_n05 vdd vdd PM W='5.4e-06*WS1' L=0.18u
MN_L08_S07 l08_n07 l08_n06 0 0 NM W='4.0500000000000002e-06*WS2' L=0.18u
MP_L08_S07 l08_n07 l08_n06 vdd vdd PM W='8.1000000000000004e-06*WS2' L=0.18u
MN_L08_S08 l08_n08 l08_n07 0 0 NM W='6.0750000000000003e-06*WS3' L=0.18u
MP_L08_S08 l08_n08 l08_n07 vdd vdd PM W='1.2150000000000001e-05*WS3' L=0.18u
MN_L08_S09 l08_n09 l08_n08 0 0 NM W='1.7999999999999999e-06*WS0' L=0.18u
MP_L08_S09 l08_n09 l08_n08 vdd vdd PM W='3.5999999999999998e-06*WS0' L=0.18u
MN_L08_S10 l08_n10 l08_n09 0 0 NM W='2.7e-06*WS1' L=0.18u
MP_L08_S10 l08_n10 l08_n09 vdd vdd PM W='5.4e-06*WS1' L=0.18u
MN_L08_S11 l08_n11 l08_n10 0 0 NM W='4.0500000000000002e-06*WS2' L=0.18u
MP_L08_S11 l08_n11 l08_n10 vdd vdd PM W='8.1000000000000004e-06*WS2' L=0.18u
RLEAK_L08 l08_n11 0 1g
MN_L09_S01 l09_n01 in 0 0 NM W='1.84e-06*WS0' L=0.18u
MP_L09_S01 l09_n01 in vdd vdd PM W='3.6799999999999999e-06*WS0' L=0.18u
MN_L09_S02 l09_n02 l09_n01 0 0 NM W='2.7600000000000003e-06*WS1' L=0.18u
MP_L09_S02 l09_n02 l09_n01 vdd vdd PM W='5.5200000000000005e-06*WS1' L=0.18u
MN_L09_S03 l09_n03 l09_n02 0 0 NM W='4.1400000000000002e-06*WS2' L=0.18u
MP_L09_S03 l09_n03 l09_n02 vdd vdd PM W='8.2800000000000003e-06*WS2' L=0.18u
MN_L09_S04 l09_n04 l09_n03 0 0 NM W='6.2099999999999998e-06*WS3' L=0.18u
MP_L09_S04 l09_n04 l09_n03 vdd vdd PM W='1.242e-05*WS3' L=0.18u
MN_L09_S05 l09_n05 l09_n04 0 0 NM W='1.84e-06*WS0' L=0.18u
MP_L09_S05 l09_n05 l09_n04 vdd vdd PM W='3.6799999999999999e-06*WS0' L=0.18u
MN_L09_S06 l09_n06 l09_n05 0 0 NM W='2.7600000000000003e-06*WS1' L=0.18u
MP_L09_S06 l09_n06 l09_n05 vdd vdd PM W='5.5200000000000005e-06*WS1' L=0.18u
MN_L09_S07 l09_n07 l09_n06 0 0 NM W='4.1400000000000002e-06*WS2' L=0.18u
MP_L09_S07 l09_n07 l09_n06 vdd vdd PM W='8.2800000000000003e-06*WS2' L=0.18u
MN_L09_S08 l09_n08 l09_n07 0 0 NM W='6.2099999999999998e-06*WS3' L=0.18u
MP_L09_S08 l09_n08 l09_n07 vdd vdd PM W='1.242e-05*WS3' L=0.18u
MN_L09_S09 l09_n09 l09_n08 0 0 NM W='1.84e-06*WS0' L=0.18u
MP_L09_S09 l09_n09 l09_n08 vdd vdd PM W='3.6799999999999999e-06*WS0' L=0.18u
MN_L09_S10 l09_n10 l09_n09 0 0 NM W='2.7600000000000003e-06*WS1' L=0.18u
MP_L09_S10 l09_n10 l09_n09 vdd vdd PM W='5.5200000000000005e-06*WS1' L=0.18u
MN_L09_S11 l09_n11 l09_n10 0 0 NM W='4.1400000000000002e-06*WS2' L=0.18u
MP_L09_S11 l09_n11 l09_n10 vdd vdd PM W='8.2800000000000003e-06*WS2' L=0.18u
RLEAK_L09 l09_n11 0 1g
MN_L10_S01 l10_n01 in 0 0 NM W='1.8799999999999998e-06*WS0' L=0.18u
MP_L10_S01 l10_n01 in vdd vdd PM W='3.7599999999999996e-06*WS0' L=0.18u
MN_L10_S02 l10_n02 l10_n01 0 0 NM W='2.8200000000000001e-06*WS1' L=0.18u
MP_L10_S02 l10_n02 l10_n01 vdd vdd PM W='5.6400000000000002e-06*WS1' L=0.18u
MN_L10_S03 l10_n03 l10_n02 0 0 NM W='4.2300000000000002e-06*WS2' L=0.18u
MP_L10_S03 l10_n03 l10_n02 vdd vdd PM W='8.4600000000000003e-06*WS2' L=0.18u
MN_L10_S04 l10_n04 l10_n03 0 0 NM W='6.3449999999999994e-06*WS3' L=0.18u
MP_L10_S04 l10_n04 l10_n03 vdd vdd PM W='1.2689999999999999e-05*WS3' L=0.18u
MN_L10_S05 l10_n05 l10_n04 0 0 NM W='1.8799999999999998e-06*WS0' L=0.18u
MP_L10_S05 l10_n05 l10_n04 vdd vdd PM W='3.7599999999999996e-06*WS0' L=0.18u
MN_L10_S06 l10_n06 l10_n05 0 0 NM W='2.8200000000000001e-06*WS1' L=0.18u
MP_L10_S06 l10_n06 l10_n05 vdd vdd PM W='5.6400000000000002e-06*WS1' L=0.18u
MN_L10_S07 l10_n07 l10_n06 0 0 NM W='4.2300000000000002e-06*WS2' L=0.18u
MP_L10_S07 l10_n07 l10_n06 vdd vdd PM W='8.4600000000000003e-06*WS2' L=0.18u
MN_L10_S08 l10_n08 l10_n07 0 0 NM W='6.3449999999999994e-06*WS3' L=0.18u
MP_L10_S08 l10_n08 l10_n07 vdd vdd PM W='1.2689999999999999e-05*WS3' L=0.18u
MN_L10_S09 l10_n09 l10_n08 0 0 NM W='1.8799999999999998e-06*WS0' L=0.18u
MP_L10_S09 l10_n09 l10_n08 vdd vdd PM W='3.7599999999999996e-06*WS0' L=0.18u
MN_L10_S10 l10_n10 l10_n09 0 0 NM W='2.8200000000000001e-06*WS1' L=0.18u
MP_L10_S10 l10_n10 l10_n09 vdd vdd PM W='5.6400000000000002e-06*WS1' L=0.18u
MN_L10_S11 l10_n11 l10_n10 0 0 NM W='4.2300000000000002e-06*WS2' L=0.18u
MP_L10_S11 l10_n11 l10_n10 vdd vdd PM W='8.4600000000000003e-06*WS2' L=0.18u
RLEAK_L10 l10_n11 0 1g
MN_L11_S01 l11_n01 in 0 0 NM W='1.9199999999999998e-06*WS0' L=0.18u
MP_L11_S01 l11_n01 in vdd vdd PM W='3.8399999999999997e-06*WS0' L=0.18u
MN_L11_S02 l11_n02 l11_n01 0 0 NM W='2.88e-06*WS1' L=0.18u
MP_L11_S02 l11_n02 l11_n01 vdd vdd PM W='5.7599999999999999e-06*WS1' L=0.18u
MN_L11_S03 l11_n03 l11_n02 0 0 NM W='4.3200000000000001e-06*WS2' L=0.18u
MP_L11_S03 l11_n03 l11_n02 vdd vdd PM W='8.6400000000000003e-06*WS2' L=0.18u
MN_L11_S04 l11_n04 l11_n03 0 0 NM W='6.4799999999999998e-06*WS3' L=0.18u
MP_L11_S04 l11_n04 l11_n03 vdd vdd PM W='1.296e-05*WS3' L=0.18u
MN_L11_S05 l11_n05 l11_n04 0 0 NM W='1.9199999999999998e-06*WS0' L=0.18u
MP_L11_S05 l11_n05 l11_n04 vdd vdd PM W='3.8399999999999997e-06*WS0' L=0.18u
MN_L11_S06 l11_n06 l11_n05 0 0 NM W='2.88e-06*WS1' L=0.18u
MP_L11_S06 l11_n06 l11_n05 vdd vdd PM W='5.7599999999999999e-06*WS1' L=0.18u
MN_L11_S07 l11_n07 l11_n06 0 0 NM W='4.3200000000000001e-06*WS2' L=0.18u
MP_L11_S07 l11_n07 l11_n06 vdd vdd PM W='8.6400000000000003e-06*WS2' L=0.18u
MN_L11_S08 l11_n08 l11_n07 0 0 NM W='6.4799999999999998e-06*WS3' L=0.18u
MP_L11_S08 l11_n08 l11_n07 vdd vdd PM W='1.296e-05*WS3' L=0.18u
MN_L11_S09 l11_n09 l11_n08 0 0 NM W='1.9199999999999998e-06*WS0' L=0.18u
MP_L11_S09 l11_n09 l11_n08 vdd vdd PM W='3.8399999999999997e-06*WS0' L=0.18u
MN_L11_S10 l11_n10 l11_n09 0 0 NM W='2.88e-06*WS1' L=0.18u
MP_L11_S10 l11_n10 l11_n09 vdd vdd PM W='5.7599999999999999e-06*WS1' L=0.18u
MN_L11_S11 l11_n11 l11_n10 0 0 NM W='4.3200000000000001e-06*WS2' L=0.18u
MP_L11_S11 l11_n11 l11_n10 vdd vdd PM W='8.6400000000000003e-06*WS2' L=0.18u
RLEAK_L11 l11_n11 0 1g
MN_L12_S01 l12_n01 in 0 0 NM W='1.9599999999999999e-06*WS0' L=0.18u
MP_L12_S01 l12_n01 in vdd vdd PM W='3.9199999999999997e-06*WS0' L=0.18u
MN_L12_S02 l12_n02 l12_n01 0 0 NM W='2.9400000000000002e-06*WS1' L=0.18u
MP_L12_S02 l12_n02 l12_n01 vdd vdd PM W='5.8800000000000005e-06*WS1' L=0.18u
MN_L12_S03 l12_n03 l12_n02 0 0 NM W='4.4100000000000001e-06*WS2' L=0.18u
MP_L12_S03 l12_n03 l12_n02 vdd vdd PM W='8.8200000000000003e-06*WS2' L=0.18u
MN_L12_S04 l12_n04 l12_n03 0 0 NM W='6.6149999999999993e-06*WS3' L=0.18u
MP_L12_S04 l12_n04 l12_n03 vdd vdd PM W='1.3229999999999999e-05*WS3' L=0.18u
MN_L12_S05 l12_n05 l12_n04 0 0 NM W='1.9599999999999999e-06*WS0' L=0.18u
MP_L12_S05 l12_n05 l12_n04 vdd vdd PM W='3.9199999999999997e-06*WS0' L=0.18u
MN_L12_S06 l12_n06 l12_n05 0 0 NM W='2.9400000000000002e-06*WS1' L=0.18u
MP_L12_S06 l12_n06 l12_n05 vdd vdd PM W='5.8800000000000005e-06*WS1' L=0.18u
MN_L12_S07 l12_n07 l12_n06 0 0 NM W='4.4100000000000001e-06*WS2' L=0.18u
MP_L12_S07 l12_n07 l12_n06 vdd vdd PM W='8.8200000000000003e-06*WS2' L=0.18u
MN_L12_S08 l12_n08 l12_n07 0 0 NM W='6.6149999999999993e-06*WS3' L=0.18u
MP_L12_S08 l12_n08 l12_n07 vdd vdd PM W='1.3229999999999999e-05*WS3' L=0.18u
MN_L12_S09 l12_n09 l12_n08 0 0 NM W='1.9599999999999999e-06*WS0' L=0.18u
MP_L12_S09 l12_n09 l12_n08 vdd vdd PM W='3.9199999999999997e-06*WS0' L=0.18u
MN_L12_S10 l12_n10 l12_n09 0 0 NM W='2.9400000000000002e-06*WS1' L=0.18u
MP_L12_S10 l12_n10 l12_n09 vdd vdd PM W='5.8800000000000005e-06*WS1' L=0.18u
MN_L12_S11 l12_n11 l12_n10 0 0 NM W='4.4100000000000001e-06*WS2' L=0.18u
MP_L12_S11 l12_n11 l12_n10 vdd vdd PM W='8.8200000000000003e-06*WS2' L=0.18u
RLEAK_L12 l12_n11 0 1g
MN_L13_S01 l13_n01 in 0 0 NM W='1.9999999999999999e-06*WS0' L=0.18u
MP_L13_S01 l13_n01 in vdd vdd PM W='3.9999999999999998e-06*WS0' L=0.18u
MN_L13_S02 l13_n02 l13_n01 0 0 NM W='3.0000000000000001e-06*WS1' L=0.18u
MP_L13_S02 l13_n02 l13_n01 vdd vdd PM W='6.0000000000000002e-06*WS1' L=0.18u
MN_L13_S03 l13_n03 l13_n02 0 0 NM W='4.5000000000000001e-06*WS2' L=0.18u
MP_L13_S03 l13_n03 l13_n02 vdd vdd PM W='9.0000000000000002e-06*WS2' L=0.18u
MN_L13_S04 l13_n04 l13_n03 0 0 NM W='6.7499999999999997e-06*WS3' L=0.18u
MP_L13_S04 l13_n04 l13_n03 vdd vdd PM W='1.3499999999999999e-05*WS3' L=0.18u
MN_L13_S05 l13_n05 l13_n04 0 0 NM W='1.9999999999999999e-06*WS0' L=0.18u
MP_L13_S05 l13_n05 l13_n04 vdd vdd PM W='3.9999999999999998e-06*WS0' L=0.18u
MN_L13_S06 l13_n06 l13_n05 0 0 NM W='3.0000000000000001e-06*WS1' L=0.18u
MP_L13_S06 l13_n06 l13_n05 vdd vdd PM W='6.0000000000000002e-06*WS1' L=0.18u
MN_L13_S07 l13_n07 l13_n06 0 0 NM W='4.5000000000000001e-06*WS2' L=0.18u
MP_L13_S07 l13_n07 l13_n06 vdd vdd PM W='9.0000000000000002e-06*WS2' L=0.18u
MN_L13_S08 l13_n08 l13_n07 0 0 NM W='6.7499999999999997e-06*WS3' L=0.18u
MP_L13_S08 l13_n08 l13_n07 vdd vdd PM W='1.3499999999999999e-05*WS3' L=0.18u
MN_L13_S09 l13_n09 l13_n08 0 0 NM W='1.9999999999999999e-06*WS0' L=0.18u
MP_L13_S09 l13_n09 l13_n08 vdd vdd PM W='3.9999999999999998e-06*WS0' L=0.18u
MN_L13_S10 l13_n10 l13_n09 0 0 NM W='3.0000000000000001e-06*WS1' L=0.18u
MP_L13_S10 l13_n10 l13_n09 vdd vdd PM W='6.0000000000000002e-06*WS1' L=0.18u
MN_L13_S11 l13_n11 l13_n10 0 0 NM W='4.5000000000000001e-06*WS2' L=0.18u
MP_L13_S11 l13_n11 l13_n10 vdd vdd PM W='9.0000000000000002e-06*WS2' L=0.18u
RLEAK_L13 l13_n11 0 1g
MN_L14_S01 l14_n01 in 0 0 NM W='2.04e-06*WS0' L=0.18u
MP_L14_S01 l14_n01 in vdd vdd PM W='4.0799999999999999e-06*WS0' L=0.18u
MN_L14_S02 l14_n02 l14_n01 0 0 NM W='3.0599999999999999e-06*WS1' L=0.18u
MP_L14_S02 l14_n02 l14_n01 vdd vdd PM W='6.1199999999999999e-06*WS1' L=0.18u
MN_L14_S03 l14_n03 l14_n02 0 0 NM W='4.5900000000000001e-06*WS2' L=0.18u
MP_L14_S03 l14_n03 l14_n02 vdd vdd PM W='9.1800000000000002e-06*WS2' L=0.18u
MN_L14_S04 l14_n04 l14_n03 0 0 NM W='6.8850000000000001e-06*WS3' L=0.18u
MP_L14_S04 l14_n04 l14_n03 vdd vdd PM W='1.377e-05*WS3' L=0.18u
MN_L14_S05 l14_n05 l14_n04 0 0 NM W='2.04e-06*WS0' L=0.18u
MP_L14_S05 l14_n05 l14_n04 vdd vdd PM W='4.0799999999999999e-06*WS0' L=0.18u
MN_L14_S06 l14_n06 l14_n05 0 0 NM W='3.0599999999999999e-06*WS1' L=0.18u
MP_L14_S06 l14_n06 l14_n05 vdd vdd PM W='6.1199999999999999e-06*WS1' L=0.18u
MN_L14_S07 l14_n07 l14_n06 0 0 NM W='4.5900000000000001e-06*WS2' L=0.18u
MP_L14_S07 l14_n07 l14_n06 vdd vdd PM W='9.1800000000000002e-06*WS2' L=0.18u
MN_L14_S08 l14_n08 l14_n07 0 0 NM W='6.8850000000000001e-06*WS3' L=0.18u
MP_L14_S08 l14_n08 l14_n07 vdd vdd PM W='1.377e-05*WS3' L=0.18u
MN_L14_S09 l14_n09 l14_n08 0 0 NM W='2.04e-06*WS0' L=0.18u
MP_L14_S09 l14_n09 l14_n08 vdd vdd PM W='4.0799999999999999e-06*WS0' L=0.18u
MN_L14_S10 l14_n10 l14_n09 0 0 NM W='3.0599999999999999e-06*WS1' L=0.18u
MP_L14_S10 l14_n10 l14_n09 vdd vdd PM W='6.1199999999999999e-06*WS1' L=0.18u
MN_L14_S11 l14_n11 l14_n10 0 0 NM W='4.5900000000000001e-06*WS2' L=0.18u
MP_L14_S11 l14_n11 l14_n10 vdd vdd PM W='9.1800000000000002e-06*WS2' L=0.18u
RLEAK_L14 l14_n11 0 1g
MN_L15_S01 l15_n01 in 0 0 NM W='2.08e-06*WS0' L=0.18u
MP_L15_S01 l15_n01 in vdd vdd PM W='4.16e-06*WS0' L=0.18u
MN_L15_S02 l15_n02 l15_n01 0 0 NM W='3.1200000000000002e-06*WS1' L=0.18u
MP_L15_S02 l15_n02 l15_n01 vdd vdd PM W='6.2400000000000004e-06*WS1' L=0.18u
MN_L15_S03 l15_n03 l15_n02 0 0 NM W='4.6800000000000001e-06*WS2' L=0.18u
MP_L15_S03 l15_n03 l15_n02 vdd vdd PM W='9.3600000000000002e-06*WS2' L=0.18u
MN_L15_S04 l15_n04 l15_n03 0 0 NM W='7.0199999999999997e-06*WS3' L=0.18u
MP_L15_S04 l15_n04 l15_n03 vdd vdd PM W='1.4039999999999999e-05*WS3' L=0.18u
MN_L15_S05 l15_n05 l15_n04 0 0 NM W='2.08e-06*WS0' L=0.18u
MP_L15_S05 l15_n05 l15_n04 vdd vdd PM W='4.16e-06*WS0' L=0.18u
MN_L15_S06 l15_n06 l15_n05 0 0 NM W='3.1200000000000002e-06*WS1' L=0.18u
MP_L15_S06 l15_n06 l15_n05 vdd vdd PM W='6.2400000000000004e-06*WS1' L=0.18u
MN_L15_S07 l15_n07 l15_n06 0 0 NM W='4.6800000000000001e-06*WS2' L=0.18u
MP_L15_S07 l15_n07 l15_n06 vdd vdd PM W='9.3600000000000002e-06*WS2' L=0.18u
MN_L15_S08 l15_n08 l15_n07 0 0 NM W='7.0199999999999997e-06*WS3' L=0.18u
MP_L15_S08 l15_n08 l15_n07 vdd vdd PM W='1.4039999999999999e-05*WS3' L=0.18u
MN_L15_S09 l15_n09 l15_n08 0 0 NM W='2.08e-06*WS0' L=0.18u
MP_L15_S09 l15_n09 l15_n08 vdd vdd PM W='4.16e-06*WS0' L=0.18u
MN_L15_S10 l15_n10 l15_n09 0 0 NM W='3.1200000000000002e-06*WS1' L=0.18u
MP_L15_S10 l15_n10 l15_n09 vdd vdd PM W='6.2400000000000004e-06*WS1' L=0.18u
MN_L15_S11 l15_n11 l15_n10 0 0 NM W='4.6800000000000001e-06*WS2' L=0.18u
MP_L15_S11 l15_n11 l15_n10 vdd vdd PM W='9.3600000000000002e-06*WS2' L=0.18u
RLEAK_L15 l15_n11 0 1g
MN_L16_S01 l16_n01 in 0 0 NM W='2.12e-06*WS0' L=0.18u
MP_L16_S01 l16_n01 in vdd vdd PM W='4.2400000000000001e-06*WS0' L=0.18u
MN_L16_S02 l16_n02 l16_n01 0 0 NM W='3.18e-06*WS1' L=0.18u
MP_L16_S02 l16_n02 l16_n01 vdd vdd PM W='6.3600000000000001e-06*WS1' L=0.18u
MN_L16_S03 l16_n03 l16_n02 0 0 NM W='4.7700000000000001e-06*WS2' L=0.18u
MP_L16_S03 l16_n03 l16_n02 vdd vdd PM W='9.5400000000000001e-06*WS2' L=0.18u
MN_L16_S04 l16_n04 l16_n03 0 0 NM W='7.1550000000000001e-06*WS3' L=0.18u
MP_L16_S04 l16_n04 l16_n03 vdd vdd PM W='1.431e-05*WS3' L=0.18u
MN_L16_S05 l16_n05 l16_n04 0 0 NM W='2.12e-06*WS0' L=0.18u
MP_L16_S05 l16_n05 l16_n04 vdd vdd PM W='4.2400000000000001e-06*WS0' L=0.18u
MN_L16_S06 l16_n06 l16_n05 0 0 NM W='3.18e-06*WS1' L=0.18u
MP_L16_S06 l16_n06 l16_n05 vdd vdd PM W='6.3600000000000001e-06*WS1' L=0.18u
MN_L16_S07 l16_n07 l16_n06 0 0 NM W='4.7700000000000001e-06*WS2' L=0.18u
MP_L16_S07 l16_n07 l16_n06 vdd vdd PM W='9.5400000000000001e-06*WS2' L=0.18u
MN_L16_S08 l16_n08 l16_n07 0 0 NM W='7.1550000000000001e-06*WS3' L=0.18u
MP_L16_S08 l16_n08 l16_n07 vdd vdd PM W='1.431e-05*WS3' L=0.18u
MN_L16_S09 l16_n09 l16_n08 0 0 NM W='2.12e-06*WS0' L=0.18u
MP_L16_S09 l16_n09 l16_n08 vdd vdd PM W='4.2400000000000001e-06*WS0' L=0.18u
MN_L16_S10 l16_n10 l16_n09 0 0 NM W='3.18e-06*WS1' L=0.18u
MP_L16_S10 l16_n10 l16_n09 vdd vdd PM W='6.3600000000000001e-06*WS1' L=0.18u
MN_L16_S11 l16_n11 l16_n10 0 0 NM W='4.7700000000000001e-06*WS2' L=0.18u
MP_L16_S11 l16_n11 l16_n10 vdd vdd PM W='9.5400000000000001e-06*WS2' L=0.18u
RLEAK_L16 l16_n11 0 1g
MN_L17_S01 l17_n01 in 0 0 NM W='2.1600000000000001e-06*WS0' L=0.18u
MP_L17_S01 l17_n01 in vdd vdd PM W='4.3200000000000001e-06*WS0' L=0.18u
MN_L17_S02 l17_n02 l17_n01 0 0 NM W='3.2400000000000003e-06*WS1' L=0.18u
MP_L17_S02 l17_n02 l17_n01 vdd vdd PM W='6.4800000000000006e-06*WS1' L=0.18u
MN_L17_S03 l17_n03 l17_n02 0 0 NM W='4.8600000000000001e-06*WS2' L=0.18u
MP_L17_S03 l17_n03 l17_n02 vdd vdd PM W='9.7200000000000001e-06*WS2' L=0.18u
MN_L17_S04 l17_n04 l17_n03 0 0 NM W='7.2900000000000005e-06*WS3' L=0.18u
MP_L17_S04 l17_n04 l17_n03 vdd vdd PM W='1.4580000000000001e-05*WS3' L=0.18u
MN_L17_S05 l17_n05 l17_n04 0 0 NM W='2.1600000000000001e-06*WS0' L=0.18u
MP_L17_S05 l17_n05 l17_n04 vdd vdd PM W='4.3200000000000001e-06*WS0' L=0.18u
MN_L17_S06 l17_n06 l17_n05 0 0 NM W='3.2400000000000003e-06*WS1' L=0.18u
MP_L17_S06 l17_n06 l17_n05 vdd vdd PM W='6.4800000000000006e-06*WS1' L=0.18u
MN_L17_S07 l17_n07 l17_n06 0 0 NM W='4.8600000000000001e-06*WS2' L=0.18u
MP_L17_S07 l17_n07 l17_n06 vdd vdd PM W='9.7200000000000001e-06*WS2' L=0.18u
MN_L17_S08 l17_n08 l17_n07 0 0 NM W='7.2900000000000005e-06*WS3' L=0.18u
MP_L17_S08 l17_n08 l17_n07 vdd vdd PM W='1.4580000000000001e-05*WS3' L=0.18u
MN_L17_S09 l17_n09 l17_n08 0 0 NM W='2.1600000000000001e-06*WS0' L=0.18u
MP_L17_S09 l17_n09 l17_n08 vdd vdd PM W='4.3200000000000001e-06*WS0' L=0.18u
MN_L17_S10 l17_n10 l17_n09 0 0 NM W='3.2400000000000003e-06*WS1' L=0.18u
MP_L17_S10 l17_n10 l17_n09 vdd vdd PM W='6.4800000000000006e-06*WS1' L=0.18u
MN_L17_S11 l17_n11 l17_n10 0 0 NM W='4.8600000000000001e-06*WS2' L=0.18u
MP_L17_S11 l17_n11 l17_n10 vdd vdd PM W='9.7200000000000001e-06*WS2' L=0.18u
RLEAK_L17 l17_n11 0 1g
MN_L18_S01 l18_n01 in 0 0 NM W='2.2000000000000001e-06*WS0' L=0.18u
MP_L18_S01 l18_n01 in vdd vdd PM W='4.4000000000000002e-06*WS0' L=0.18u
MN_L18_S02 l18_n02 l18_n01 0 0 NM W='3.3000000000000002e-06*WS1' L=0.18u
MP_L18_S02 l18_n02 l18_n01 vdd vdd PM W='6.6000000000000003e-06*WS1' L=0.18u
MN_L18_S03 l18_n03 l18_n02 0 0 NM W='4.9500000000000009e-06*WS2' L=0.18u
MP_L18_S03 l18_n03 l18_n02 vdd vdd PM W='9.9000000000000018e-06*WS2' L=0.18u
MN_L18_S04 l18_n04 l18_n03 0 0 NM W='7.4250000000000001e-06*WS3' L=0.18u
MP_L18_S04 l18_n04 l18_n03 vdd vdd PM W='1.485e-05*WS3' L=0.18u
MN_L18_S05 l18_n05 l18_n04 0 0 NM W='2.2000000000000001e-06*WS0' L=0.18u
MP_L18_S05 l18_n05 l18_n04 vdd vdd PM W='4.4000000000000002e-06*WS0' L=0.18u
MN_L18_S06 l18_n06 l18_n05 0 0 NM W='3.3000000000000002e-06*WS1' L=0.18u
MP_L18_S06 l18_n06 l18_n05 vdd vdd PM W='6.6000000000000003e-06*WS1' L=0.18u
MN_L18_S07 l18_n07 l18_n06 0 0 NM W='4.9500000000000009e-06*WS2' L=0.18u
MP_L18_S07 l18_n07 l18_n06 vdd vdd PM W='9.9000000000000018e-06*WS2' L=0.18u
MN_L18_S08 l18_n08 l18_n07 0 0 NM W='7.4250000000000001e-06*WS3' L=0.18u
MP_L18_S08 l18_n08 l18_n07 vdd vdd PM W='1.485e-05*WS3' L=0.18u
MN_L18_S09 l18_n09 l18_n08 0 0 NM W='2.2000000000000001e-06*WS0' L=0.18u
MP_L18_S09 l18_n09 l18_n08 vdd vdd PM W='4.4000000000000002e-06*WS0' L=0.18u
MN_L18_S10 l18_n10 l18_n09 0 0 NM W='3.3000000000000002e-06*WS1' L=0.18u
MP_L18_S10 l18_n10 l18_n09 vdd vdd PM W='6.6000000000000003e-06*WS1' L=0.18u
MN_L18_S11 l18_n11 l18_n10 0 0 NM W='4.9500000000000009e-06*WS2' L=0.18u
MP_L18_S11 l18_n11 l18_n10 vdd vdd PM W='9.9000000000000018e-06*WS2' L=0.18u
RLEAK_L18 l18_n11 0 1g
MN_L19_S01 l19_n01 in 0 0 NM W='2.2400000000000002e-06*WS0' L=0.18u
MP_L19_S01 l19_n01 in vdd vdd PM W='4.4800000000000003e-06*WS0' L=0.18u
MN_L19_S02 l19_n02 l19_n01 0 0 NM W='3.3600000000000004e-06*WS1' L=0.18u
MP_L19_S02 l19_n02 l19_n01 vdd vdd PM W='6.7200000000000009e-06*WS1' L=0.18u
MN_L19_S03 l19_n03 l19_n02 0 0 NM W='5.0400000000000009e-06*WS2' L=0.18u
MP_L19_S03 l19_n03 l19_n02 vdd vdd PM W='1.0080000000000002e-05*WS2' L=0.18u
MN_L19_S04 l19_n04 l19_n03 0 0 NM W='7.5600000000000005e-06*WS3' L=0.18u
MP_L19_S04 l19_n04 l19_n03 vdd vdd PM W='1.5120000000000001e-05*WS3' L=0.18u
MN_L19_S05 l19_n05 l19_n04 0 0 NM W='2.2400000000000002e-06*WS0' L=0.18u
MP_L19_S05 l19_n05 l19_n04 vdd vdd PM W='4.4800000000000003e-06*WS0' L=0.18u
MN_L19_S06 l19_n06 l19_n05 0 0 NM W='3.3600000000000004e-06*WS1' L=0.18u
MP_L19_S06 l19_n06 l19_n05 vdd vdd PM W='6.7200000000000009e-06*WS1' L=0.18u
MN_L19_S07 l19_n07 l19_n06 0 0 NM W='5.0400000000000009e-06*WS2' L=0.18u
MP_L19_S07 l19_n07 l19_n06 vdd vdd PM W='1.0080000000000002e-05*WS2' L=0.18u
MN_L19_S08 l19_n08 l19_n07 0 0 NM W='7.5600000000000005e-06*WS3' L=0.18u
MP_L19_S08 l19_n08 l19_n07 vdd vdd PM W='1.5120000000000001e-05*WS3' L=0.18u
MN_L19_S09 l19_n09 l19_n08 0 0 NM W='2.2400000000000002e-06*WS0' L=0.18u
MP_L19_S09 l19_n09 l19_n08 vdd vdd PM W='4.4800000000000003e-06*WS0' L=0.18u
MN_L19_S10 l19_n10 l19_n09 0 0 NM W='3.3600000000000004e-06*WS1' L=0.18u
MP_L19_S10 l19_n10 l19_n09 vdd vdd PM W='6.7200000000000009e-06*WS1' L=0.18u
MN_L19_S11 l19_n11 l19_n10 0 0 NM W='5.0400000000000009e-06*WS2' L=0.18u
MP_L19_S11 l19_n11 l19_n10 vdd vdd PM W='1.0080000000000002e-05*WS2' L=0.18u
RLEAK_L19 l19_n11 0 1g
MN_L20_S01 l20_n01 in 0 0 NM W='2.2800000000000002e-06*WS0' L=0.18u
MP_L20_S01 l20_n01 in vdd vdd PM W='4.5600000000000004e-06*WS0' L=0.18u
MN_L20_S02 l20_n02 l20_n01 0 0 NM W='3.4200000000000003e-06*WS1' L=0.18u
MP_L20_S02 l20_n02 l20_n01 vdd vdd PM W='6.8400000000000006e-06*WS1' L=0.18u
MN_L20_S03 l20_n03 l20_n02 0 0 NM W='5.1300000000000009e-06*WS2' L=0.18u
MP_L20_S03 l20_n03 l20_n02 vdd vdd PM W='1.0260000000000002e-05*WS2' L=0.18u
MN_L20_S04 l20_n04 l20_n03 0 0 NM W='7.695e-06*WS3' L=0.18u
MP_L20_S04 l20_n04 l20_n03 vdd vdd PM W='1.539e-05*WS3' L=0.18u
MN_L20_S05 l20_n05 l20_n04 0 0 NM W='2.2800000000000002e-06*WS0' L=0.18u
MP_L20_S05 l20_n05 l20_n04 vdd vdd PM W='4.5600000000000004e-06*WS0' L=0.18u
MN_L20_S06 l20_n06 l20_n05 0 0 NM W='3.4200000000000003e-06*WS1' L=0.18u
MP_L20_S06 l20_n06 l20_n05 vdd vdd PM W='6.8400000000000006e-06*WS1' L=0.18u
MN_L20_S07 l20_n07 l20_n06 0 0 NM W='5.1300000000000009e-06*WS2' L=0.18u
MP_L20_S07 l20_n07 l20_n06 vdd vdd PM W='1.0260000000000002e-05*WS2' L=0.18u
MN_L20_S08 l20_n08 l20_n07 0 0 NM W='7.695e-06*WS3' L=0.18u
MP_L20_S08 l20_n08 l20_n07 vdd vdd PM W='1.539e-05*WS3' L=0.18u
MN_L20_S09 l20_n09 l20_n08 0 0 NM W='2.2800000000000002e-06*WS0' L=0.18u
MP_L20_S09 l20_n09 l20_n08 vdd vdd PM W='4.5600000000000004e-06*WS0' L=0.18u
MN_L20_S10 l20_n10 l20_n09 0 0 NM W='3.4200000000000003e-06*WS1' L=0.18u
MP_L20_S10 l20_n10 l20_n09 vdd vdd PM W='6.8400000000000006e-06*WS1' L=0.18u
MN_L20_S11 l20_n11 l20_n10 0 0 NM W='5.1300000000000009e-06*WS2' L=0.18u
MP_L20_S11 l20_n11 l20_n10 vdd vdd PM W='1.0260000000000002e-05*WS2' L=0.18u
RLEAK_L20 l20_n11 0 1g
MN_L21_S01 l21_n01 in 0 0 NM W='2.3200000000000002e-06*WS0' L=0.18u
MP_L21_S01 l21_n01 in vdd vdd PM W='4.6400000000000005e-06*WS0' L=0.18u
MN_L21_S02 l21_n02 l21_n01 0 0 NM W='3.4800000000000006e-06*WS1' L=0.18u
MP_L21_S02 l21_n02 l21_n01 vdd vdd PM W='6.9600000000000011e-06*WS1' L=0.18u
MN_L21_S03 l21_n03 l21_n02 0 0 NM W='5.2200000000000008e-06*WS2' L=0.18u
MP_L21_S03 l21_n03 l21_n02 vdd vdd PM W='1.0440000000000002e-05*WS2' L=0.18u
MN_L21_S04 l21_n04 l21_n03 0 0 NM W='7.8300000000000013e-06*WS3' L=0.18u
MP_L21_S04 l21_n04 l21_n03 vdd vdd PM W='1.5660000000000003e-05*WS3' L=0.18u
MN_L21_S05 l21_n05 l21_n04 0 0 NM W='2.3200000000000002e-06*WS0' L=0.18u
MP_L21_S05 l21_n05 l21_n04 vdd vdd PM W='4.6400000000000005e-06*WS0' L=0.18u
MN_L21_S06 l21_n06 l21_n05 0 0 NM W='3.4800000000000006e-06*WS1' L=0.18u
MP_L21_S06 l21_n06 l21_n05 vdd vdd PM W='6.9600000000000011e-06*WS1' L=0.18u
MN_L21_S07 l21_n07 l21_n06 0 0 NM W='5.2200000000000008e-06*WS2' L=0.18u
MP_L21_S07 l21_n07 l21_n06 vdd vdd PM W='1.0440000000000002e-05*WS2' L=0.18u
MN_L21_S08 l21_n08 l21_n07 0 0 NM W='7.8300000000000013e-06*WS3' L=0.18u
MP_L21_S08 l21_n08 l21_n07 vdd vdd PM W='1.5660000000000003e-05*WS3' L=0.18u
MN_L21_S09 l21_n09 l21_n08 0 0 NM W='2.3200000000000002e-06*WS0' L=0.18u
MP_L21_S09 l21_n09 l21_n08 vdd vdd PM W='4.6400000000000005e-06*WS0' L=0.18u
MN_L21_S10 l21_n10 l21_n09 0 0 NM W='3.4800000000000006e-06*WS1' L=0.18u
MP_L21_S10 l21_n10 l21_n09 vdd vdd PM W='6.9600000000000011e-06*WS1' L=0.18u
MN_L21_S11 l21_n11 l21_n10 0 0 NM W='5.2200000000000008e-06*WS2' L=0.18u
MP_L21_S11 l21_n11 l21_n10 vdd vdd PM W='1.0440000000000002e-05*WS2' L=0.18u
RLEAK_L21 l21_n11 0 1g
MN_L22_S01 l22_n01 in 0 0 NM W='2.3599999999999999e-06*WS0' L=0.18u
MP_L22_S01 l22_n01 in vdd vdd PM W='4.7199999999999997e-06*WS0' L=0.18u
MN_L22_S02 l22_n02 l22_n01 0 0 NM W='3.54e-06*WS1' L=0.18u
MP_L22_S02 l22_n02 l22_n01 vdd vdd PM W='7.08e-06*WS1' L=0.18u
MN_L22_S03 l22_n03 l22_n02 0 0 NM W='5.31e-06*WS2' L=0.18u
MP_L22_S03 l22_n03 l22_n02 vdd vdd PM W='1.062e-05*WS2' L=0.18u
MN_L22_S04 l22_n04 l22_n03 0 0 NM W='7.9649999999999991e-06*WS3' L=0.18u
MP_L22_S04 l22_n04 l22_n03 vdd vdd PM W='1.5929999999999998e-05*WS3' L=0.18u
MN_L22_S05 l22_n05 l22_n04 0 0 NM W='2.3599999999999999e-06*WS0' L=0.18u
MP_L22_S05 l22_n05 l22_n04 vdd vdd PM W='4.7199999999999997e-06*WS0' L=0.18u
MN_L22_S06 l22_n06 l22_n05 0 0 NM W='3.54e-06*WS1' L=0.18u
MP_L22_S06 l22_n06 l22_n05 vdd vdd PM W='7.08e-06*WS1' L=0.18u
MN_L22_S07 l22_n07 l22_n06 0 0 NM W='5.31e-06*WS2' L=0.18u
MP_L22_S07 l22_n07 l22_n06 vdd vdd PM W='1.062e-05*WS2' L=0.18u
MN_L22_S08 l22_n08 l22_n07 0 0 NM W='7.9649999999999991e-06*WS3' L=0.18u
MP_L22_S08 l22_n08 l22_n07 vdd vdd PM W='1.5929999999999998e-05*WS3' L=0.18u
MN_L22_S09 l22_n09 l22_n08 0 0 NM W='2.3599999999999999e-06*WS0' L=0.18u
MP_L22_S09 l22_n09 l22_n08 vdd vdd PM W='4.7199999999999997e-06*WS0' L=0.18u
MN_L22_S10 l22_n10 l22_n09 0 0 NM W='3.54e-06*WS1' L=0.18u
MP_L22_S10 l22_n10 l22_n09 vdd vdd PM W='7.08e-06*WS1' L=0.18u
MN_L22_S11 l22_n11 l22_n10 0 0 NM W='5.31e-06*WS2' L=0.18u
MP_L22_S11 l22_n11 l22_n10 vdd vdd PM W='1.062e-05*WS2' L=0.18u
RLEAK_L22 l22_n11 0 1g
MN_L23_S01 l23_n01 in 0 0 NM W='2.3999999999999999e-06*WS0' L=0.18u
MP_L23_S01 l23_n01 in vdd vdd PM W='4.7999999999999998e-06*WS0' L=0.18u
MN_L23_S02 l23_n02 l23_n01 0 0 NM W='3.5999999999999998e-06*WS1' L=0.18u
MP_L23_S02 l23_n02 l23_n01 vdd vdd PM W='7.1999999999999997e-06*WS1' L=0.18u
MN_L23_S03 l23_n03 l23_n02 0 0 NM W='5.4e-06*WS2' L=0.18u
MP_L23_S03 l23_n03 l23_n02 vdd vdd PM W='1.08e-05*WS2' L=0.18u
MN_L23_S04 l23_n04 l23_n03 0 0 NM W='8.0999999999999987e-06*WS3' L=0.18u
MP_L23_S04 l23_n04 l23_n03 vdd vdd PM W='1.6199999999999997e-05*WS3' L=0.18u
MN_L23_S05 l23_n05 l23_n04 0 0 NM W='2.3999999999999999e-06*WS0' L=0.18u
MP_L23_S05 l23_n05 l23_n04 vdd vdd PM W='4.7999999999999998e-06*WS0' L=0.18u
MN_L23_S06 l23_n06 l23_n05 0 0 NM W='3.5999999999999998e-06*WS1' L=0.18u
MP_L23_S06 l23_n06 l23_n05 vdd vdd PM W='7.1999999999999997e-06*WS1' L=0.18u
MN_L23_S07 l23_n07 l23_n06 0 0 NM W='5.4e-06*WS2' L=0.18u
MP_L23_S07 l23_n07 l23_n06 vdd vdd PM W='1.08e-05*WS2' L=0.18u
MN_L23_S08 l23_n08 l23_n07 0 0 NM W='8.0999999999999987e-06*WS3' L=0.18u
MP_L23_S08 l23_n08 l23_n07 vdd vdd PM W='1.6199999999999997e-05*WS3' L=0.18u
MN_L23_S09 l23_n09 l23_n08 0 0 NM W='2.3999999999999999e-06*WS0' L=0.18u
MP_L23_S09 l23_n09 l23_n08 vdd vdd PM W='4.7999999999999998e-06*WS0' L=0.18u
MN_L23_S10 l23_n10 l23_n09 0 0 NM W='3.5999999999999998e-06*WS1' L=0.18u
MP_L23_S10 l23_n10 l23_n09 vdd vdd PM W='7.1999999999999997e-06*WS1' L=0.18u
MN_L23_S11 l23_n11 l23_n10 0 0 NM W='5.4e-06*WS2' L=0.18u
MP_L23_S11 l23_n11 l23_n10 vdd vdd PM W='1.08e-05*WS2' L=0.18u
RLEAK_L23 l23_n11 0 1g
MN_L24_S01 l24_n01 in 0 0 NM W='2.4399999999999999e-06*WS0' L=0.18u
MP_L24_S01 l24_n01 in vdd vdd PM W='4.8799999999999999e-06*WS0' L=0.18u
MN_L24_S02 l24_n02 l24_n01 0 0 NM W='3.6600000000000001e-06*WS1' L=0.18u
MP_L24_S02 l24_n02 l24_n01 vdd vdd PM W='7.3200000000000002e-06*WS1' L=0.18u
MN_L24_S03 l24_n03 l24_n02 0 0 NM W='5.49e-06*WS2' L=0.18u
MP_L24_S03 l24_n03 l24_n02 vdd vdd PM W='1.098e-05*WS2' L=0.18u
MN_L24_S04 l24_n04 l24_n03 0 0 NM W='8.2349999999999999e-06*WS3' L=0.18u
MP_L24_S04 l24_n04 l24_n03 vdd vdd PM W='1.647e-05*WS3' L=0.18u
MN_L24_S05 l24_n05 l24_n04 0 0 NM W='2.4399999999999999e-06*WS0' L=0.18u
MP_L24_S05 l24_n05 l24_n04 vdd vdd PM W='4.8799999999999999e-06*WS0' L=0.18u
MN_L24_S06 l24_n06 l24_n05 0 0 NM W='3.6600000000000001e-06*WS1' L=0.18u
MP_L24_S06 l24_n06 l24_n05 vdd vdd PM W='7.3200000000000002e-06*WS1' L=0.18u
MN_L24_S07 l24_n07 l24_n06 0 0 NM W='5.49e-06*WS2' L=0.18u
MP_L24_S07 l24_n07 l24_n06 vdd vdd PM W='1.098e-05*WS2' L=0.18u
MN_L24_S08 l24_n08 l24_n07 0 0 NM W='8.2349999999999999e-06*WS3' L=0.18u
MP_L24_S08 l24_n08 l24_n07 vdd vdd PM W='1.647e-05*WS3' L=0.18u
MN_L24_S09 l24_n09 l24_n08 0 0 NM W='2.4399999999999999e-06*WS0' L=0.18u
MP_L24_S09 l24_n09 l24_n08 vdd vdd PM W='4.8799999999999999e-06*WS0' L=0.18u
MN_L24_S10 l24_n10 l24_n09 0 0 NM W='3.6600000000000001e-06*WS1' L=0.18u
MP_L24_S10 l24_n10 l24_n09 vdd vdd PM W='7.3200000000000002e-06*WS1' L=0.18u
MN_L24_S11 l24_n11 l24_n10 0 0 NM W='5.49e-06*WS2' L=0.18u
MP_L24_S11 l24_n11 l24_n10 vdd vdd PM W='1.098e-05*WS2' L=0.18u
RLEAK_L24 l24_n11 0 1g
MN_L25_S01 l25_n01 in 0 0 NM W='2.48e-06*WS0' L=0.18u
MP_L25_S01 l25_n01 in vdd vdd PM W='4.9599999999999999e-06*WS0' L=0.18u
MN_L25_S02 l25_n02 l25_n01 0 0 NM W='3.72e-06*WS1' L=0.18u
MP_L25_S02 l25_n02 l25_n01 vdd vdd PM W='7.4399999999999999e-06*WS1' L=0.18u
MN_L25_S03 l25_n03 l25_n02 0 0 NM W='5.5799999999999999e-06*WS2' L=0.18u
MP_L25_S03 l25_n03 l25_n02 vdd vdd PM W='1.116e-05*WS2' L=0.18u
MN_L25_S04 l25_n04 l25_n03 0 0 NM W='8.3699999999999995e-06*WS3' L=0.18u
MP_L25_S04 l25_n04 l25_n03 vdd vdd PM W='1.6739999999999999e-05*WS3' L=0.18u
MN_L25_S05 l25_n05 l25_n04 0 0 NM W='2.48e-06*WS0' L=0.18u
MP_L25_S05 l25_n05 l25_n04 vdd vdd PM W='4.9599999999999999e-06*WS0' L=0.18u
MN_L25_S06 l25_n06 l25_n05 0 0 NM W='3.72e-06*WS1' L=0.18u
MP_L25_S06 l25_n06 l25_n05 vdd vdd PM W='7.4399999999999999e-06*WS1' L=0.18u
MN_L25_S07 l25_n07 l25_n06 0 0 NM W='5.5799999999999999e-06*WS2' L=0.18u
MP_L25_S07 l25_n07 l25_n06 vdd vdd PM W='1.116e-05*WS2' L=0.18u
MN_L25_S08 l25_n08 l25_n07 0 0 NM W='8.3699999999999995e-06*WS3' L=0.18u
MP_L25_S08 l25_n08 l25_n07 vdd vdd PM W='1.6739999999999999e-05*WS3' L=0.18u
MN_L25_S09 l25_n09 l25_n08 0 0 NM W='2.48e-06*WS0' L=0.18u
MP_L25_S09 l25_n09 l25_n08 vdd vdd PM W='4.9599999999999999e-06*WS0' L=0.18u
MN_L25_S10 l25_n10 l25_n09 0 0 NM W='3.72e-06*WS1' L=0.18u
MP_L25_S10 l25_n10 l25_n09 vdd vdd PM W='7.4399999999999999e-06*WS1' L=0.18u
MN_L25_S11 l25_n11 l25_n10 0 0 NM W='5.5799999999999999e-06*WS2' L=0.18u
MP_L25_S11 l25_n11 l25_n10 vdd vdd PM W='1.116e-05*WS2' L=0.18u
RLEAK_L25 l25_n11 0 1g
.dc VIN 0 1.8 0.1
.measure dc l01_lo find v(l01_n11) at=0
.measure dc l01_hi find v(l01_n11) at=1.8
.measure dc l01_th find v(in) when v(l01_n01)=0.9 cross=1
.measure dc l07_lo find v(l07_n11) at=0
.measure dc l07_hi find v(l07_n11) at=1.8
.measure dc l07_th find v(in) when v(l07_n01)=0.9 cross=1
.measure dc l13_lo find v(l13_n11) at=0
.measure dc l13_hi find v(l13_n11) at=1.8
.measure dc l13_th find v(in) when v(l13_n01)=0.9 cross=1
.measure dc l19_lo find v(l19_n11) at=0
.measure dc l19_hi find v(l19_n11) at=1.8
.measure dc l19_th find v(in) when v(l19_n01)=0.9 cross=1
.measure dc l25_lo find v(l25_n11) at=0
.measure dc l25_hi find v(l25_n11) at=1.8
.measure dc l25_th find v(in) when v(l25_n01)=0.9 cross=1
.measure dc peak_pwr max par('-v(vdd)*i(vdd)')
.alter p000001
.param VTHN=0.4416960313164332 VTHP=-0.4532675514368949 U0N=0.054724914205196845 U0P=0.020404897023237323 RDSWN=97.576109085495176 RDSWP=116.85102835365008 VSATN=75478.12811154114 VSATP=77062.760408557355 ETA0N=0.080435244689600047 ETA0P=0.076607981130987865 WS0=1.0178994352543229 WS1=0.98263236961936784 WS2=1.0415687192824925 WS3=1.0547795127571304
.alter p000002
.param VTHN=0.46491769949940609 VTHP=-0.45865466766240509 U0N=0.046727852190048734 U0P=0.018425943840254033 RDSWN=104.78000927547589 RDSWP=113.35504216102532 VSATN=78677.730953723207 VSATP=74876.706575867516 ETA0N=0.080084308024550105 ETA0P=0.077970201016476295 WS0=1.088283844172778 WS1=0.9342640679167451 WS2=1.0713255540580897 WS3=0.99484078422620237
.alter p000003
.param VTHN=0.45667128430832954 VTHP=-0.47250069269426731 U0N=0.047759465422216825 U0P=0.01891063529661248 RDSWN=108.53063414393735 RDSWP=108.96779365498017 VSATN=86118.979285999318 VSATP=76162.810464638082 ETA0N=0.075014434473199387 ETA0P=0.078502203644315385 WS0=1.0371247722231445 WS1=1.0550425731897928 WS2=0.92532304738848803 WS3=1.0866314150251111
.alter p000004
.param VTHN=0.42887517271908149 VTHP=-0.44641858129778245 U0N=0.052076722159991443 U0P=0.018133164379206663 RDSWN=97.825918937038011 RDSWP=114.04744445207079 VSATN=81628.125581516491 VSATP=75439.647769938412 ETA0N=0.073789423157502532 ETA0P=0.087891071905445164 WS0=0.90157231341960808 WS1=0.90084149641583744 WS2=1.0885479940738818 WS3=1.0643917650893009
.alter p000005
.param VTHN=0.42062976228570609 VTHP=-0.47532511469164346 U0N=0.045986391342465655 U0P=0.0207865039080629 RDSWN=91.57719414651001 RDSWP=124.15476689493943 VSATN=73421.275473975227 VSATP=86011.616771304543 ETA0N=0.082291906621727029 ETA0P=0.075283092756474268 WS0=1.0738836304791741 WS1=1.0747705751756211 WS2=0.92023215427767324 WS3=1.0906466519882607
.alter p000006
.param VTHN=0.42138780776688017 VTHP=-0.42322228605583578 U0N=0.047359720325786003 U0P=0.02076627523936582 RDSWN=94.635862262155541 RDSWP=112.08739725960683 VSATN=85948.727223747919 VSATP=86077.072288854921 ETA0N=0.085976119657146022 ETA0P=0.086354164174372069 WS0=0.93949918453018033 WS1=1.0184266608053729 WS2=1.0827542532567387 WS3=0.92158507920998622
.alter p000007
.param VTHN=0.46812422049213187 VTHP=-0.43730854524382734 U0N=0.053452486719753722 U0P=0.01818899910651512 RDSWN=107.54347614911727 RDSWP=122.48052288265656 VSATN=75740.432771009859 VSATP=87484.796977788574 ETA0N=0.074216356099342698 ETA0P=0.081576772900871897 WS0=0.93697611759489019 WS1=0.99170689585539273 WS2=1.0460596227919086 WS3=1.0478662646431864
.alter p000008
.param VTHN=0.4736271953963182 VTHP=-0.42787136856370245 U0N=0.049086589780280382 U0P=0.01880149311864698 RDSWN=100.57080509450454 RDSWP=128.01324363712268 VSATN=87896.275986940629 VSATP=86794.766491619899 ETA0N=0.08277948353215947 ETA0P=0.074727202431229933 WS0=1.0558060639899538 WS1=0.93721643908579577 WS2=1.0958492461173266 WS3=0.93104808354788071
.alter p000009
.param VTHN=0.46113088651321543 VTHP=-0.45951877739644703 U0N=0.045507117306345879 U0P=0.020092225027548007 RDSWN=94.306886023369273 RDSWP=120.88687407697961 VSATN=76243.390353242459 VSATP=75871.08660228677 ETA0N=0.077750377671547605 ETA0P=0.081609608179626911 WS0=0.95857051896890766 WS1=0.90002993035741052 WS2=0.92645191792125892 WS3=1.0399229736609898
.alter p000010
.param VTHN=0.45404444337550692 VTHP=-0.44526248748522901 U0N=0.047378691626468468 U0P=0.018332848775408413 RDSWN=105.74139629776036 RDSWP=121.14472570783518 VSATN=79112.571770226961 VSATP=83688.404214029433 ETA0N=0.075485982983022268 ETA0P=0.077061072350568374 WS0=1.066898081309466 WS1=1.0980220808569094 WS2=1.0324536632477501 WS3=0.9884622483738883
.alter p000011
.param VTHN=0.47323242409370297 VTHP=-0.43391134824729866 U0N=0.053011773794342021 U0P=0.019130334161729566 RDSWN=105.83447483771815 RDSWP=116.28629336043042 VSATN=87760.933355770903 VSATP=72638.982889843814 ETA0N=0.081096953358928414 ETA0P=0.079421337906943515 WS0=0.98024539086601803 WS1=0.9505882583911015 WS2=0.92869247836939661 WS3=1.0253284893467645
.alter p000012
.param VTHN=0.4457378098221248 VTHP=-0.43591502358579559 U0N=0.046081427408600217 U0P=0.019018886208324128 RDSWN=100.75969591064674 RDSWP=128.96916030165517 VSATN=82272.583008271075 VSATP=84638.780188128192 ETA0N=0.085799870204509257 ETA0P=0.073691760059541089 WS0=1.0060757674169805 WS1=0.99009381928389717 WS2=0.96957565372771537 WS3=0.94463840119088727
.alter p000013
.param VTHN=0.45036997572507498 VTHP=-0.4340934330331116 U0N=0.053082025219420834 U0P=0.019657839028668422 RDSWN=102.06972799660751 RDSWP=109.35921718691797 VSATN=72763.615192496713 VSATP=85827.969343109493 ETA0N=0.085059623457668293 ETA0P=0.074821141390591234 WS0=0.9824837531255064 WS1=0.96624779296170427 WS2=1.0981016814617566 WS3=0.98283645456232938
.alter p000014
.param VTHN=0.42589150210194737 VTHP=-0.42981690055205241 U0N=0.048164641217214137 U0P=0.019412399622300285 RDSWN=99.436018622185287 RDSWP=123.64500754437195 VSATN=73588.834523961501 VSATP=74235.51483267505 ETA0N=0.086360138397820571 ETA0P=0.086477637980987454 WS0=1.0582909393322271 WS1=1.0796556259643169 WS2=0.97456747233434349 WS3=1.0291435933117381
.alter p000015
.param VTHN=0.42792153684236295 VTHP=-0.47714511023425005 U0N=0.05421779283834248 U0P=0.020563508130432343 RDSWN=98.043428282352693 RDSWP=113.19830233631106 VSATN=80985.015256673767 VSATP=79777.186760795579 ETA0N=0.078487142864782769 ETA0P=0.076857098800277052 WS0=0.96399362279344558 WS1=0.98157719369537166 WS2=1.0154306890387488 WS3=1.0216187323107231
.alter p000016
.param VTHN=0.47674935245046757 VTHP=-0.44581627164719484 U0N=0.046233018664728794 U0P=0.020195342769425861 RDSWN=109.31106631417734 RDSWP=109.00832995046163 VSATN=87776.501810399874 VSATP=86663.120256277107 ETA0N=0.079188562609036561 ETA0P=0.075250016709981771 WS0=1.0948795373682341 WS1=0.99300590520476761 WS2=1.055170189845112 WS3=0.92163185957686344
.alter p000017
.param VTHN=0.44287269005987751 VTHP=-0.4352500826314506 U0N=0.047225057657365913 U0P=0.019912416127296551 RDSWN=100.63185444199689 RDSWP=127.30887342008364 VSATN=83511.479932428163 VSATP=84911.693166896846 ETA0N=0.073439848765491811 ETA0P=0.086202000222877037 WS0=1.080573450728747 WS1=1.0541935177168966 WS2=1.086358713999735 WS3=0.92504829077261341
.alter p000018
.param VTHN=0.46604716207932573 VTHP=-0.47550367160792506 U0N=0.045185374062198601 U0P=0.021108287998445632 RDSWN=96.205353602716386 RDSWP=125.61571421186781 VSATN=87952.394238217239 VSATP=84254.51210770497 ETA0N=0.084544398602124038 ETA0P=0.085858793349139567 WS0=1.0964529786623103 WS1=1.032720695443232 WS2=1.0612142051958302 WS3=0.90314198747664542
.alter p000019
.param VTHN=0.47137355387929986 VTHP=-0.45640444557404863 U0N=0.045116013756376139 U0P=0.018075756325022993 RDSWN=90.183670874467026 RDSWP=129.68397319477307 VSATN=85893.354737531408 VSATP=72815.64950966055 ETA0N=0.087294283187993704 ETA0P=0.080982601471054752 WS0=1.0747660793456244 WS1=0.91878363108923977 WS2=1.0123204116125364 WS3=0.94050457079420668
.alter p000020
.param VTHN=0.43311604125471032 VTHP=-0.47315509651398119 U0N=0.054061359524004218 U0P=0.020083384712130663 RDSWN=106.08302853246711 RDSWP=114.21853675167812 VSATN=75219.776303912004 VSATP=76653.837331110335 ETA0N=0.072322389970367246 ETA0P=0.076230974102417068 WS0=1.0514721438728025 WS1=0.92719657647082343 WS2=1.085869201012754 WS3=0.96401929352660687
.alter p000021
.param VTHN=0.44021866282092953 VTHP=-0.47482897166145061 U0N=0.048292798380353018 U0P=0.020395006090049284 RDSWN=99.828885694364118 RDSWP=125.5678243174227 VSATN=81903.00999981942 VSATP=76278.891424847738 ETA0N=0.085710326198217293 ETA0P=0.073820357667436165 WS0=0.97002283308540305 WS1=0.9731366507195931 WS2=0.97214393910002261 WS3=0.9349773137206645
.alter p000022
.param VTHN=0.42152232425274616 VTHP=-0.47530837791992298 U0N=0.046448617222289774 U0P=0.020965040861766353 RDSWN=90.138097737193505 RDSWP=116.88919706658662 VSATN=74781.488135226886 VSATP=81041.320639165322 ETA0N=0.078379454496909862 ETA0P=0.078832430967311268 WS0=1.0590704049775483 WS1=1.0229222201027284 WS2=0.96308057283001058 WS3=1.0582823737011522
.alter p000023
.param VTHN=0.43615073866887327 VTHP=-0.42484588756280217 U0N=0.046807746755207637 U0P=0.018411680687166296 RDSWN=101.75102834374303 RDSWP=119.40069411214294 VSATN=84953.304986411138 VSATP=86271.005467163879 ETA0N=0.077721012603189643 ETA0P=0.075313543565217189 WS0=0.91555805101699095 WS1=0.90268618613158125 WS2=0.90377693121061842 WS3=1.0853196881546683
.alter p000024
.param VTHN=0.44811353170729173 VTHP=-0.45973419983862435 U0N=0.051222934873950368 U0P=0.021735422988188133 RDSWN=95.560481923687647 RDSWP=119.78772822279343 VSATN=72294.607105678035 VSATP=80888.471157468681 ETA0N=0.086036459082838898 ETA0P=0.084359178431292814 WS0=1.0810919897082478 WS1=1.058282046453378 WS2=1.0733395678090241 WS3=1.0960030475448317
.alter p000025
.param VTHN=0.46347000109739844 VTHP=-0.47167013958761739 U0N=0.049493375689986477 U0P=0.021479623573732856 RDSWN=96.395186292875891 RDSWP=124.94534427570062 VSATN=87590.251807589666 VSATP=79884.806273938666 ETA0N=0.085930980028019674 ETA0P=0.087907460721221867 WS0=0.93221648033921811 WS1=0.94352440909611923 WS2=1.0175544411869304 WS3=0.93312056439399493
.alter p000026
.param VTHN=0.42635239407932257 VTHP=-0.47989281563450942 U0N=0.047781291029107151 U0P=0.019247115849112127 RDSWN=90.510378040265394 RDSWP=115.1871628388667 VSATN=81279.557420326935 VSATP=72657.435695942782 ETA0N=0.087951333408454041 ETA0P=0.072297498279842762 WS0=1.0324966749193374 WS1=1.0674986238501356 WS2=0.97734788735536315 WS3=1.0374011557634957
.alter p000027
.param VTHN=0.44995152318846893 VTHP=-0.44670856146444371 U0N=0.051931172188713549 U0P=0.018416867717233245 RDSWN=104.2274247060127 RDSWP=129.89528921418753 VSATN=82548.108706397063 VSATP=83306.696522737941 ETA0N=0.083228667010698199 ETA0P=0.072023166687584836 WS0=0.91332643307738171 WS1=0.98913681852598612 WS2=1.0740678271606534 WS3=1.0473282034822495
.alter p000028
.param VTHN=0.4422583098660669 VTHP=-0.44421038991070694 U0N=0.05092425119371314 U0P=0.018343863216181731 RDSWN=104.5362162156559 RDSWP=110.84639744626251 VSATN=85187.037228827336 VSATP=80350.567437264646 ETA0N=0.077911555662780047 ETA0P=0.086539115326642671 WS0=0.92353367591394087 WS1=0.984333940213584 WS2=1.0130094396220228 WS3=1.0346900055980421
.alter p000029
.param VTHN=0.44555345860267698 VTHP=-0.44261648723499125 U0N=0.050559644696496195 U0P=0.018640458501275634 RDSWN=106.58006660200634 RDSWP=112.32380062661163 VSATN=74586.583640263038 VSATP=82128.673460117992 ETA0N=0.08667743240234338 ETA0P=0.074292402385943437 WS0=0.97323922865900203 WS1=1.0651045609752303 WS2=0.93876836828057864 WS3=1.0787970813581143
.alter p000030
.param VTHN=0.42680667809947664 VTHP=-0.44913844393550084 U0N=0.051869826518594786 U0P=0.021824661941313654 RDSWN=95.30079015219134 RDSWP=111.8509309257565 VSATN=75448.482501931489 VSATP=82195.847583136128 ETA0N=0.084195711686672989 ETA0P=0.080818362735527546 WS0=1.0816562513599099 WS1=1.0707627357752338 WS2=0.93645953459520237 WS3=0.98527471638167752
.alter p000031
.param VTHN=0.44758651059088733 VTHP=-0.45746761883613146 U0N=0.052597752318542752 U0P=0.01968939023636361 RDSWN=106.42398503475491 RDSWP=128.42776420494448 VSATN=83801.56157434333 VSATP=80863.193145113459 ETA0N=0.077643450485670784 ETA0P=0.084431566803319147 WS0=0.97268405770387478 WS1=0.97339317643257695 WS2=0.99147288541703593 WS3=0.940186764712167
.alter p000032
.param VTHN=0.43048552338114809 VTHP=-0.44917414658714955 U0N=0.049398810383216155 U0P=0.019681651852989 RDSWN=95.955872948152717 RDSWP=118.93335608846371 VSATN=81514.058281224148 VSATP=79243.276362645163 ETA0N=0.076135564590116056 ETA0P=0.074103198172691898 WS0=0.93753743902729358 WS1=0.90045936127411041 WS2=0.9042648717469185 WS3=0.95430923169218529
.alter p000033
.param VTHN=0.43547092054522285 VTHP=-0.4779551408880014 U0N=0.047885154379800655 U0P=0.020685695757301226 RDSWN=109.46266832613426 RDSWP=113.81377056020602 VSATN=73870.06881566385 VSATP=82521.31016410864 ETA0N=0.073826023309681216 ETA0P=0.072995499437995409 WS0=0.95947070630656339 WS1=1.0457600937107618 WS2=1.0026007577091345 WS3=1.032502377990089
.alter p000034
.param VTHN=0.4750069118989193 VTHP=-0.45446375218854573 U0N=0.053992213048173837 U0P=0.019478088205638473 RDSWN=107.64258071721981 RDSWP=130.53796108700152 VSATN=87424.721512912089 VSATP=81161.02439038147 ETA0N=0.083699182575617301 ETA0P=0.083172811016394579 WS0=1.0901091756691998 WS1=0.9094865627199481 WS2=0.949665096879304 WS3=1.0746162940705291
.alter p000035
.param VTHN=0.42002857946247868 VTHP=-0.4794789200993731 U0N=0.047720550572638194 U0P=0.020666920916797296 RDSWN=105.70654165126143 RDSWP=122.69506171305578 VSATN=84797.435157815547 VSATP=76804.609628656501 ETA0N=0.072681913443992566 ETA0P=0.076904680161051148 WS0=0.96637383766074592 WS1=1.0936261048364564 WS2=0.97963402345185935 WS3=1.0355523577848089
.alter p000036
.param VTHN=0.44941504008520444 VTHP=-0.44624441591507163 U0N=0.053684313112904614 U0P=0.019873354421621598 RDSWN=109.09200030598491 RDSWP=114.94906565121849 VSATN=87010.765804406357 VSATP=86977.928589783056 ETA0N=0.072406256073965017 ETA0P=0.082682429648919795 WS0=0.92243668953790825 WS1=0.98662150403053395 WS2=0.95467021186856349 WS3=0.90516027205108962
.alter p000037
.param VTHN=0.4287053473595443 VTHP=-0.45623222688532261 U0N=0.050782948822173407 U0P=0.018865391318337574 RDSWN=106.26867668728664 RDSWP=119.05687682870453 VSATN=77771.426841183042 VSATP=85657.001907128317 ETA0N=0.076296600482907873 ETA0P=0.087338531638395042 WS0=0.96451998508297054 WS1=1.0418039639230114 WS2=0.93405471114098249 WS3=0.99081727783982265
.alter p000038
.param VTHN=0.42458274308321353 VTHP=-0.47806377439067577 U0N=0.051969044693871973 U0P=0.019262255708281474 RDSWN=104.18988483679888 RDSWP=113.2889853306604 VSATN=75854.525088645882 VSATP=77452.056460172389 ETA0N=0.072904227261383944 ETA0P=0.080833532221615392 WS0=1.0100307982564265 WS1=1.0794540382318014 WS2=0.97191753715423601 WS3=0.90669682718237377
.alter p000039
.param VTHN=0.45717023761875675 VTHP=-0.42944388733541572 U0N=0.050941033190008964 U0P=0.021024022536584478 RDSWN=97.84216610760528 RDSWP=109.92650186672385 VSATN=83909.961067306358 VSATP=84697.572208260506 ETA0N=0.087700623715637943 ETA0P=0.085288018444640401 WS0=1.0412226683457102 WS1=1.0393012297346951 WS2=1.0249780124903607 WS3=0.91745826771112737
.alter p000040
.param VTHN=0.46778139479323116 VTHP=-0.43598382154775595 U0N=0.053140011941643341 U0P=0.018548038888764756 RDSWN=109.37466476243233 RDSWP=118.07077845905815 VSATN=84324.624879808471 VSATP=81495.178213255218 ETA0N=0.078906689591196802 ETA0P=0.072877226973487558 WS0=1.0793979829922353 WS1=0.9399813134488183 WS2=1.0731697143228258 WS3=0.91956741754512905
.alter p000041
.param VTHN=0.47100534002471717 VTHP=-0.46200227947617656 U0N=0.045158988858499095 U0P=0.020030983874784438 RDSWN=101.81989911574331 RDSWP=129.57539528703131 VSATN=79609.333317704324 VSATP=73391.502997183954 ETA0N=0.077419018761324759 ETA0P=0.087324900990737947 WS0=1.0410708099910131 WS1=1.0245041584057519 WS2=1.0789593296323989 WS3=0.91661862032866914
.alter p000042
.param VTHN=0.42561960453719627 VTHP=-0.45064991379263297 U0N=0.050201049879777387 U0P=0.01810205584092929 RDSWN=97.600977846740051 RDSWP=110.75021786510801 VSATN=81678.734762206252 VSATP=75393.866319815672 ETA0N=0.078161520720021332 ETA0P=0.072415097204934692 WS0=1.0221607141475535 WS1=1.00001683979112 WS2=0.90728371569014388 WS3=0.9797329312456019
.alter p000043
.param VTHN=0.44532747810209117 VTHP=-0.42759172877968071 U0N=0.048031772286232226 U0P=0.021366349436951385 RDSWN=105.04569267953801 RDSWP=113.78949375346234 VSATN=76446.794228214625 VSATP=72875.858231383565 ETA0N=0.077145944838808433 ETA0P=0.077129732554176697 WS0=1.0498357623538193 WS1=0.93248513981746228 WS2=1.0892795182562733 WS3=1.0834808574238894
.alter p000044
.param VTHN=0.43058979548298804 VTHP=-0.45604953686275951 U0N=0.049513290253177578 U0P=0.019086037056737774 RDSWN=102.196818793909 RDSWP=114.30593553731023 VSATN=79430.234545168321 VSATP=81123.007784516129 ETA0N=0.074949993262998241 ETA0P=0.072850046001397412 WS0=0.92753009167949496 WS1=0.93790839516877411 WS2=1.0944061887196246 WS3=1.067865861867864
.alter p000045
.param VTHN=0.45347449468731343 VTHP=-0.44405365209971914 U0N=0.046325897469542639 U0P=0.020511657400195914 RDSWN=97.385957303320083 RDSWP=123.03546335859474 VSATN=73998.761404523 VSATP=83341.732770111965 ETA0N=0.073505186685461021 ETA0P=0.083030500875796956 WS0=1.0329253595250902 WS1=0.93682889901940902 WS2=1.0245484709204107 WS3=0.95584000995769391
.alter p000046
.param VTHN=0.4563734013712033 VTHP=-0.45836057254024848 U0N=0.049616656607798411 U0P=0.018586295227923644 RDSWN=106.38235400516439 RDSWP=108.72621259851023 VSATN=86820.963010539213 VSATP=81570.366272906453 ETA0N=0.087915790018983475 ETA0P=0.073524655099527936 WS0=0.93522403433596446 WS1=0.98573571500983825 WS2=0.94377548544454137 WS3=1.040180872670591
.alter p000047
.param VTHN=0.45560585135731285 VTHP=-0.45542288585423768 U0N=0.046405194005114253 U0P=0.020220628619400414 RDSWN=92.400738383780151 RDSWP=118.59436788796789 VSATN=84145.212761759627 VSATP=77820.421426597532 ETA0N=0.081996302339492608 ETA0P=0.078255431735585565 WS0=1.0643246055459181 WS1=0.94732895200260658 WS2=1.0752863583373411 WS3=0.95931442576254111
.alter p000048
.param VTHN=0.4517027298299045 VTHP=-0.42468934034669981 U0N=0.04613100620876056 U0P=0.01926702226937799 RDSWN=94.326812634922916 RDSWP=109.68279094963547 VSATN=78009.586160662555 VSATP=83487.857708905183 ETA0N=0.086369320485201198 ETA0P=0.075705644640004968 WS0=1.0997282464855502 WS1=0.93559586814103068 WS2=0.97811729241485978 WS3=1.077939244451217
.alter p000049
.param VTHN=0.42999917579907726 VTHP=-0.46871542292817364 U0N=0.046035428527725381 U0P=0.019543602024094827 RDSWN=93.761999762338931 RDSWP=113.86304929849372 VSATN=75985.889055620966 VSATP=82422.711456301928 ETA0N=0.083979556093815438 ETA0P=0.079057848078298243 WS0=1.0447677001657778 WS1=0.95695384795244898 WS2=0.90231261620065517 WS3=1.0928830344806484
.alter p000050
.param VTHN=0.46363813507284807 VTHP=-0.4732681575155035 U0N=0.053055771484750852 U0P=0.02146782308507094 RDSWN=93.037110311190901 RDSWP=119.24363684970596 VSATN=82996.772098513815 VSATP=73319.430498770729 ETA0N=0.076494586583277471 ETA0P=0.074597090995898424 WS0=1.0829653158641086 WS1=1.019090520420338 WS2=1.0689450563873257 WS3=0.98883061412290751
.alter p000051
.param VTHN=0.42568472605604846 VTHP=-0.47604283219673516 U0N=0.052008337307326326 U0P=0.021082834866528385 RDSWN=98.751006695936496 RDSWP=118.22446386115855 VSATN=82396.758081112872 VSATP=74825.576384593063 ETA0N=0.085503578879775943 ETA0P=0.076628546151294732 WS0=1.0516543753209358 WS1=1.0387647733078869 WS2=0.90184632378203744 WS3=1.0883083421514372
.alter p000052
.param VTHN=0.47427497348471997 VTHP=-0.43573056086105189 U0N=0.045662739415240641 U0P=0.018678861678279649 RDSWN=96.017122147510733 RDSWP=108.30753907866864 VSATN=78268.24681822554 VSATP=86885.781535006914 ETA0N=0.086326743644415532 ETA0P=0.08749646777773136 WS0=1.0836304974719386 WS1=1.0045718157807526 WS2=1.0387334672034698 WS3=1.0715197072101093
.alter p000053
.param VTHN=0.4387197610030163 VTHP=-0.45578819815331034 U0N=0.052681042849300135 U0P=0.021772477230276331 RDSWN=108.23624582480348 RDSWP=117.10186778618321 VSATN=86942.930308159368 VSATP=78559.364927800969 ETA0N=0.084996589461650784 ETA0P=0.072927899844541857 WS0=1.0865307945159748 WS1=1.026376990598862 WS2=0.9213358524868217 WS3=0.90744184792464133
.alter p000054
.param VTHN=0.42096600903295744 VTHP=-0.43536511836647501 U0N=0.052402246673039124 U0P=0.018262751503662099 RDSWN=96.961901390993461 RDSWP=108.86211837156694 VSATN=86255.632779014646 VSATP=79732.410899135342 ETA0N=0.084950423211661935 ETA0P=0.08579808180406312 WS0=0.99111059950781399 WS1=1.0758987206992301 WS2=0.94843149651447067 WS3=0.97908055562452223
.alter p000055
.param VTHN=0.46083074780405536 VTHP=-0.47560107968651016 U0N=0.05003538221183406 U0P=0.019807636689720728 RDSWN=102.8492334112821 RDSWP=117.8515380838255 VSATN=85784.482785451066 VSATP=76696.667640823202 ETA0N=0.087820948609501709 ETA0P=0.080775886047891585 WS0=1.0357697897181193 WS1=1.0571671936330866 WS2=0.98994505906484143 WS3=0.99403002624672665
.alter p000056
.param VTHN=0.42112127232281038 VTHP=-0.43566367414251117 U0N=0.049459249700067022 U0P=0.01936357701329082 RDSWN=98.144376889060268 RDSWP=127.35043396187717 VSATN=87301.505219629151 VSATP=82644.295158891095 ETA0N=0.079852767745440312 ETA0P=0.072474350365891935 WS0=0.94371505373518938 WS1=1.0682225989983025 WS2=1.0389993853120634 WS3=0.9391652832396441
.alter p000057
.param VTHN=0.44739103112232775 VTHP=-0.43186220889832194 U0N=0.045201630518539503 U0P=0.018696456667809339 RDSWN=97.678579915815419 RDSWP=129.12780292306894 VSATN=84756.486491420888 VSATP=74518.689626259569 ETA0N=0.084344907069911768 ETA0P=0.082793600383146204 WS0=1.044846807148494 WS1=0.98506424887044453 WS2=1.0699998586606645 WS3=1.0702737002728449
.alter p000058
.param VTHN=0.47765026923166781 VTHP=-0.42456960285029766 U0N=0.052626597413023238 U0P=0.018525475353737629 RDSWN=108.96186528316366 RDSWP=130.6206647354559 VSATN=76455.714354369498 VSATP=76150.370419058963 ETA0N=0.078441470982163225 ETA0P=0.083071320282263258 WS0=1.0055197450770357 WS1=0.91460360770094207 WS2=0.94557847950196083 WS3=1.0227008825750035
.alter p000059
.param VTHN=0.42782936195148757 VTHP=-0.45381399566934838 U0N=0.054553662628066171 U0P=0.021607429190328601 RDSWN=108.64168365060777 RDSWP=126.92551078881017 VSATN=80840.828863179224 VSATP=86160.598222547036 ETA0N=0.080375233720796538 ETA0P=0.079654544303971883 WS0=1.0186891447741795 WS1=0.96912751736861202 WS2=1.0471431201783497 WS3=0.9465336716459003
.alter p000060
.param VTHN=0.43573262824976366 VTHP=-0.45179921948871271 U0N=0.053600206917510454 U0P=0.020264216999158959 RDSWN=90.52341294103033 RDSWP=109.63954297405903 VSATN=76929.674942070138 VSATP=72512.928321015657 ETA0N=0.082257325940310627 ETA0P=0.081909291069649268 WS0=0.93167660236457028 WS1=0.93470374805056167 WS2=0.99685557201789088 WS3=1.0452173688047444
.alter p000061
.param VTHN=0.45209322642141458 VTHP=-0.44513937859169328 U0N=0.046998136559248067 U0P=0.021037883516887384 RDSWN=97.912412029457812 RDSWP=115.31661154535001 VSATN=73965.317969103678 VSATP=83906.162433474674 ETA0N=0.073397723594617006 ETA0P=0.075610251640821302 WS0=1.0271805168301902 WS1=1.0624473132254042 WS2=1.0523940333126918 WS3=1.0664038641415723
.alter p000062
.param VTHN=0.44409395126468215 VTHP=-0.46646069683433722 U0N=0.054962586686987031 U0P=0.020609485131663656 RDSWN=96.505450074519729 RDSWP=115.90932120173755 VSATN=73673.639670936798 VSATP=74796.700769743504 ETA0N=0.086064299923497622 ETA0P=0.082229378293768002 WS0=1.0887302884470511 WS1=0.95154624461382764 WS2=1.0581167245109602 WS3=0.98201681729807688
.alter p000063
.param VTHN=0.4761697314967443 VTHP=-0.45854432700188164 U0N=0.049358493600455487 U0P=0.020350777988055319 RDSWN=90.764692935672812 RDSWP=120.21220017963051 VSATN=79722.822856011146 VSATP=77602.706566105902 ETA0N=0.078584952830842394 ETA0P=0.075121716844235714 WS0=1.0730551381257183 WS1=1.0623891070626066 WS2=0.90291792297738083 WS3=1.0635534658666608
.alter p000064
.param VTHN=0.44961153398790688 VTHP=-0.44227410537116629 U0N=0.050266009140177662 U0P=0.01993158763894293 RDSWN=99.137876987175275 RDSWP=110.21321538118829 VSATN=79075.322638690079 VSATP=74978.15858703226 ETA0N=0.082657299669853065 ETA0P=0.087823421674454533 WS0=1.0423658939368023 WS1=1.0527322856028716 WS2=0.96522973287514457 WS3=1.0079896609007779
.alter p000065
.param VTHN=0.43395277092943801 VTHP=-0.45733786348499045 U0N=0.052911913547899696 U0P=0.020700422237308707 RDSWN=90.282875318485566 RDSWP=125.03497971562393 VSATN=77378.705806947939 VSATP=80244.754123112725 ETA0N=0.082023359186692568 ETA0P=0.072335598008562901 WS0=0.94244485833722391 WS1=0.98473652248695276 WS2=0.94594200222759373 WS3=1.0829606321253322
.alter p000066
.param VTHN=0.4641025561423654 VTHP=-0.45220961926539138 U0N=0.0544221838464332 U0P=0.018508362529940141 RDSWN=90.634895564177469 RDSWP=123.69858767834533 VSATN=76491.211361194146 VSATP=76359.268115175888 ETA0N=0.073260283648655722 ETA0P=0.076984190709043623 WS0=1.0697159170365709 WS1=1.0804950078952662 WS2=1.0587916486556379 WS3=0.9493817468492195
.alter p000067
.param VTHN=0.44489245777482983 VTHP=-0.44063199168011202 U0N=0.052155462230137381 U0P=0.018043984158917708 RDSWN=91.406917186812024 RDSWP=109.98573289664594 VSATN=83121.282773214509 VSATP=84385.155634436131 ETA0N=0.085627721267452162 ETA0P=0.07396575990532897 WS0=0.9779599497038195 WS1=1.049772823966969 WS2=1.019982460451069 WS3=0.92726990287219735
.alter p000068
.param VTHN=0.47880690760770828 VTHP=-0.46540035757883241 U0N=0.047506428865727264 U0P=0.019308150587917579 RDSWN=94.004945901241669 RDSWP=123.14965085833038 VSATN=87204.133045071387 VSATP=82794.319475345939 ETA0N=0.084760544669316443 ETA0P=0.076473476174523297 WS0=0.9900652767273026 WS1=0.95615873437870136 WS2=1.0877072542057751 WS3=0.95190831789922881
.alter p000069
.param VTHN=0.46505496112405986 VTHP=-0.43119489972865421 U0N=0.052117747525481574 U0P=0.01906756870715166 RDSWN=90.038369640353579 RDSWP=117.98795831772436 VSATN=82180.89395284465 VSATP=73726.316373589798 ETA0N=0.085858098254644369 ETA0P=0.07480563416455957 WS0=1.0773851025230441 WS1=1.0977484368818362 WS2=1.043273221734355 WS3=1.0223221847570889
.alter p000070
.param VTHN=0.44616488096316115 VTHP=-0.42774260396053537 U0N=0.045041714506013561 U0P=0.018968247014595211 RDSWN=92.82408896037461 RDSWP=115.11584622512586 VSATN=77116.78100720112 VSATP=81721.445801054622 ETA0N=0.086599821557929252 ETA0P=0.084141094523069795 WS0=0.94126597568292625 WS1=1.0768453942711715 WS2=1.0910943332111376 WS3=1.0821734510491525
.alter p000071
.param VTHN=0.44391902727497007 VTHP=-0.4619494696429422 U0N=0.050373445028829469 U0P=0.01838789851602577 RDSWN=107.39585829516369 RDSWP=118.51557799705493 VSATN=74236.19735520528 VSATP=83237.615100818468 ETA0N=0.080104132031186201 ETA0P=0.077732246011781941 WS0=1.0704349616166973 WS1=1.0382085739007616 WS2=0.94786944643142956 WS3=0.90773990513606417
.alter p000072
.param VTHN=0.45604362312797003 VTHP=-0.46424414641378803 U0N=0.051022589748719149 U0P=0.018888122711678293 RDSWN=90.930563773167606 RDSWP=123.99958722141969 VSATN=73608.224647189461 VSATP=76918.586789702225 ETA0N=0.075944770009705759 ETA0P=0.086170038055615558 WS0=0.98218972643926883 WS1=0.95540204731731737 WS2=0.95938861722367519 WS3=0.99948392726853708
.alter p000073
.param VTHN=0.46863858272020043 VTHP=-0.44244366002862096 U0N=0.053872695483888663 U0P=0.0196487863746579 RDSWN=105.5906170353698 RDSWP=130.05877542077937 VSATN=82355.301237063584 VSATP=87558.308342531833 ETA0N=0.083616601275270624 ETA0P=0.084240566517857884 WS0=0.93843758982255787 WS1=0.93669987942250921 WS2=1.0299893353687737 WS3=1.0152480009186822
.alter p000074
.param VTHN=0.47759019487477683 VTHP=-0.47137473833924332 U0N=0.047972032163013989 U0P=0.02093536939254495 RDSWN=92.32358908617249 RDSWP=118.3801218583218 VSATN=83955.063842309159 VSATP=83102.686759345816 ETA0N=0.087342486737362127 ETA0P=0.08321842645928243 WS0=0.95517528063245505 WS1=0.93030941725110239 WS2=1.0933613344725897 WS3=0.93782341853838191
.alter p000075
.param VTHN=0.45457217835575148 VTHP=-0.46157039028015573 U0N=0.048322301454096751 U0P=0.01900086614661986 RDSWN=101.05743703578439 RDSWP=127.7579441646548 VSATN=76863.334601786031 VSATP=77869.876588762592 ETA0N=0.084536921299547471 ETA0P=0.074937328493146035 WS0=1.0355046254190867 WS1=1.0667522116249128 WS2=0.97029542661209034 WS3=1.066196895187919
.alter p000076
.param VTHN=0.46042449983096362 VTHP=-0.46762009768533769 U0N=0.045751865743166711 U0P=0.018998144629446295 RDSWN=109.07826877506474 RDSWP=120.1050284406747 VSATN=86334.037946847937 VSATP=77398.760234895715 ETA0N=0.083037168072675638 ETA0P=0.087437665183457372 WS0=1.0834069570349247 WS1=1.0778998058335127 WS2=1.0974192609997555 WS3=1.0437565550964205
.alter p000077
.param VTHN=0.45391379626695566 VTHP=-0.44717955607713877 U0N=0.051092542032677629 U0P=0.021968269237159777 RDSWN=95.535129233557043 RDSWP=119.71111725041574 VSATN=74662.523795264395 VSATP=85208.762231920686 ETA0N=0.082962297934448634 ETA0P=0.087645075810632619 WS0=1.0349171812591211 WS1=0.994355883802581 WS2=1.0995769926159937 WS3=0.96855273709194345
.alter p000078
.param VTHN=0.46981929715137322 VTHP=-0.4589773338201244 U0N=0.04661057178640815 U0P=0.020387324242097563 RDSWN=92.44946721352548 RDSWP=129.88542373198854 VSATN=72014.491771212022 VSATP=84660.229813960716 ETA0N=0.080505678705331249 ETA0P=0.07543791483274602 WS0=0.9388322964419733 WS1=1.016401241329026 WS2=0.92051082433204723 WS3=1.0675681662398815
.alter p000079
.param VTHN=0.45001230529695058 VTHP=-0.47735559406834327 U0N=0.048653391566843458 U0P=0.018826000766893954 RDSWN=93.418462047630598 RDSWP=124.90729142406553 VSATN=82046.899182433641 VSATP=83286.729663133621 ETA0N=0.085457459111114936 ETA0P=0.080547191652663178 WS0=1.0672999870699982 WS1=0.91507638066840169 WS2=0.98392922183670306 WS3=0.93832745425728215
.alter p000080
.param VTHN=0.43179513437021816 VTHP=-0.42810394727677142 U0N=0.049226032754452177 U0P=0.021958698056729897 RDSWN=99.380689152921292 RDSWP=128.86295346550401 VSATN=84654.720208803847 VSATP=74761.052776426732 ETA0N=0.078206853944812804 ETA0P=0.076877622050011585 WS0=0.92022158173691593 WS1=1.0308474057613048 WS2=1.0547451579825817 WS3=1.0171749162845631
.alter p000081
.param VTHN=0.46308860847526084 VTHP=-0.45499841460245605 U0N=0.048591425031158299 U0P=0.018499839877220255 RDSWN=97.534100795121901 RDSWP=128.54116560216843 VSATN=84371.749021445168 VSATP=72157.282135476577 ETA0N=0.077058671949227192 ETA0P=0.08094144400145771 WS0=1.0064424710408002 WS1=1.01519493480995 WS2=0.9078118149936435 WS3=1.0162858694754391
.alter p000082
.param VTHN=0.44008383386959826 VTHP=-0.4257612949290403 U0N=0.050532303052410854 U0P=0.020694320980173698 RDSWN=100.05513554830392 RDSWP=113.55083817063317 VSATN=84420.556916409201 VSATP=85665.552376113439 ETA0N=0.083932025032156077 ETA0P=0.076525045096892119 WS0=0.97220837466336585 WS1=1.0829656811362729 WS2=1.0169970733050255 WS3=1.0750735091549364
.alter p000083
.param VTHN=0.44678503161298394 VTHP=-0.4403362055171271 U0N=0.054630425134012311 U0P=0.018065324846080533 RDSWN=92.066809885654564 RDSWP=121.96830580555593 VSATN=78627.098969676415 VSATP=77571.086277557508 ETA0N=0.084105601143342673 ETA0P=0.075768582951068267 WS0=1.0117501094821837 WS1=0.90738870954132478 WS2=1.0109910532307866 WS3=0.96157359852847446
.alter p000084
.param VTHN=0.42519664108699845 VTHP=-0.43285923115064034 U0N=0.054779538323085276 U0P=0.02166388297681341 RDSWN=100.12382131784211 RDSWP=118.16981395363752 VSATN=84095.937523018438 VSATP=79185.704024570179 ETA0N=0.080596681737628031 ETA0P=0.072981274615769531 WS0=1.027812168174127 WS1=0.98066544740150929 WS2=1.0360126630037141 WS3=0.94346205788785098
.alter p000085
.param VTHN=0.42282373450531968 VTHP=-0.44612781359275877 U0N=0.047399052883125029 U0P=0.021156991833585811 RDSWN=96.540440067122873 RDSWP=111.21813153510615 VSATN=72051.971084540026 VSATP=85622.491934363716 ETA0N=0.078068804360272914 ETA0P=0.084788063175286393 WS0=0.90848978740549535 WS1=1.011759236571266 WS2=1.0592995431187053 WS3=0.99171357692278383
.alter p000086
.param VTHN=0.43212135412214775 VTHP=-0.46523287113551365 U0N=0.054376461118064906 U0P=0.019901584249713004 RDSWN=94.402882932935967 RDSWP=130.1817237266697 VSATN=77054.89302580306 VSATP=87352.630261734128 ETA0N=0.078684861645009901 ETA0P=0.079515411858744722 WS0=0.95795262651483548 WS1=1.0426549329465666 WS2=1.0607108758484367 WS3=1.0705245437206834
.alter p000087
.param VTHN=0.4370501327493449 VTHP=-0.42649520150636988 U0N=0.050844398783904989 U0P=0.020019809480256289 RDSWN=104.89575946049285 RDSWP=119.16901191404726 VSATN=84168.318506385724 VSATP=86868.265652075148 ETA0N=0.076528269604693805 ETA0P=0.086326453698323563 WS0=1.0619541117848741 WS1=0.97226860112103008 WS2=0.91264181773206898 WS3=0.98240625070473264
.alter p000088
.param VTHN=0.46256029511972735 VTHP=-0.43626069042629145 U0N=0.053916848509133079 U0P=0.019341396233433568 RDSWN=102.12645903817533 RDSWP=129.00016328648027 VSATN=79910.573456169019 VSATP=86706.086123833113 ETA0N=0.072189879633051957 ETA0P=0.078024775158409124 WS0=0.97139198432553631 WS1=1.0546456490608054 WS2=1.0181126309506208 WS3=0.93028082521188227
.alter p000089
.param VTHN=0.47466835364697946 VTHP=-0.4513865348560625 U0N=0.051842922200661362 U0P=0.021925728473034055 RDSWN=101.59346773799876 RDSWP=110.26020363135976 VSATN=83550.602667573374 VSATP=78027.176438307928 ETA0N=0.083129675956672047 ETA0P=0.083506074382652409 WS0=1.0735663854564164 WS1=1.0338380950095996 WS2=1.0600893913388412 WS3=1.0129427212440112
.alter p000090
.param VTHN=0.42696290315731833 VTHP=-0.45509655688930717 U0N=0.047674627400721974 U0P=0.020171746970856413 RDSWN=99.517535384582871 RDSWP=122.39812629184232 VSATN=73719.376672752987 VSATP=77888.211599775997 ETA0N=0.083895488498128848 ETA0P=0.074782850014141575 WS0=1.0162295602646405 WS1=0.98610157355356987 WS2=1.0375501751854519 WS3=0.95609212178837166
.alter p000091
.param VTHN=0.46578317914892192 VTHP=-0.46774706506857161 U0N=0.050984866873692455 U0P=0.021281436908375397 RDSWN=94.923005978735148 RDSWP=112.00093849925879 VSATN=79338.345075555422 VSATP=81634.780976445414 ETA0N=0.082458154374572712 ETA0P=0.076381381340577856 WS0=0.90825406391593566 WS1=1.0040940487314156 WS2=0.92345727404550515 WS3=0.98089486154164651
.alter p000092
.param VTHN=0.46244366391349684 VTHP=-0.44826530004278475 U0N=0.045561191235258508 U0P=0.020905617758436475 RDSWN=90.086979620963419 RDSWP=123.45184585182801 VSATN=79900.25173899479 VSATP=84121.239670013965 ETA0N=0.080544596265470475 ETA0P=0.083347296019077005 WS0=1.0204030933288246 WS1=0.99846734117790936 WS2=0.91565258387599568 WS3=1.0730835368379861
.alter p000093
.param VTHN=0.43041259993800779 VTHP=-0.47023814890738297 U0N=0.045831402386502018 U0P=0.0218457278091264 RDSWN=107.25848600919167 RDSWP=123.407705352817 VSATN=86463.452329568434 VSATP=80619.058417350534 ETA0N=0.084612762596901814 ETA0P=0.087729379734553692 WS0=1.0259004439289221 WS1=1.0838533512363282 WS2=0.97382492354860906 WS3=1.0695267210151733
.alter p000094
.param VTHN=0.44178762656224541 VTHP=-0.47771303604693449 U0N=0.051188634817306074 U0P=0.018948043835920723 RDSWN=95.377058024095362 RDSWP=113.40713384790244 VSATN=85127.472844687654 VSATP=79922.430702662023 ETA0N=0.072304559663896928 ETA0P=0.087867311365476264 WS0=0.91821925177067154 WS1=1.0518915080634685 WS2=1.0795403586943628 WS3=1.0124716132372162
.alter p000095
.param VTHN=0.44189636612821087 VTHP=-0.47371462953382909 U0N=0.047559356742999194 U0P=0.019451059814094382 RDSWN=90.597533341178078 RDSWP=125.91331475541064 VSATN=81442.084384707807 VSATP=83795.635943182875 ETA0N=0.076731659127970961 ETA0P=0.083303876834694202 WS0=1.0442030315828528 WS1=1.0867093399299543 WS2=1.0526711634350667 WS3=0.99291313620836319
.alter p000096
.param VTHN=0.45744544754431365 VTHP=-0.46531447188710151 U0N=0.052347823026535303 U0P=0.019072817531461447 RDSWN=95.220507165358981 RDSWP=119.94227278800126 VSATN=73344.229842769782 VSATP=87540.59554561344 ETA0N=0.082786503310962656 ETA0P=0.073885379172452748 WS0=1.0175427468870069 WS1=0.97429111675494828 WS2=1.0962600787860035 WS3=0.90805780990094331
.alter p000097
.param VTHN=0.44634089982700315 VTHP=-0.46181146572371085 U0N=0.046172532040590658 U0P=0.021174965763096517 RDSWN=108.19110924264199 RDSWP=120.3016122108038 VSATN=80424.079419609741 VSATP=81846.827937235372 ETA0N=0.075735284484670498 ETA0P=0.073406856053151739 WS0=0.92298204412398555 WS1=0.95955579846371064 WS2=1.04807433079473 WS3=0.97931278203907024
.alter p000098
.param VTHN=0.45915032464393379 VTHP=-0.43888888034856527 U0N=0.04770826997285648 U0P=0.020278514456032886 RDSWN=101.18275969283999 RDSWP=131.40968877106283 VSATN=85256.901610303961 VSATP=73160.057887956049 ETA0N=0.080257899107872344 ETA0P=0.08000591159016239 WS0=1.0321119227046107 WS1=1.0604955590479483 WS2=0.950182894699661 WS3=0.92985367332163515
.alter p000099
.param VTHN=0.44658949988151919 VTHP=-0.45528501866956128 U0N=0.053638801799752278 U0P=0.019316156920155383 RDSWN=105.33564772378222 RDSWP=126.17819599411472 VSATN=79177.749646082593 VSATP=72896.155761992806 ETA0N=0.087902231920701637 ETA0P=0.073987155409042049 WS0=0.90195021054880153 WS1=1.0506398296008628 WS2=1.0259575807962253 WS3=1.0602229693190615
.end
